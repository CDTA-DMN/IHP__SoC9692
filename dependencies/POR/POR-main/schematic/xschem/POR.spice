* NGSPICE file created from POR.ext - technology: ihp-sg13g2

.subckt POR VLDO RESET VBGR VSS
X0 a_63489_n5420.t1 a_63489_n12306.t0 VSS.t16 rhigh l=34u w=0.5u
X1 a_64841_n448.t3 a_64841_n448.t2 VLDO.t3 VLDO.t2 sg13_lv_pmos ad=0.68p pd=4.68u as=0.38p ps=2.38u w=2u l=1u
X2 a_65785_n2363.t0 a_63070_n12306.t5 RESET.t0 VSS.t0 sg13_lv_nmos ad=95f pd=0.88u as=95f ps=0.88u w=0.5u l=0.5u
X3 a_63349_1752.t0 a_63489_n5420.t0 VSS.t16 rhigh l=34u w=0.5u
X4 VLDO.t20 RESET.t5 a_65785_n2363.t2 VSS.t13 sg13_lv_nmos ad=0.34p pd=2.68u as=0.34p ps=2.68u w=1u l=0.5u
X5 RESET.t3 VSS.t14 cap_cmim l=26.98u w=26.98u
X6 a_63070_1752.t0 a_63206_n5420.t0 VSS.t19 rhigh l=34u w=0.5u
X7 a_64868_n3050.t0 a_63070_n12306.t9 VLDO.t1 VLDO.t0 sg13_lv_pmos ad=0.19p pd=1.38u as=0.19p ps=1.38u w=1u l=0.5u
X8 a_63349_1752.t1 a_63349_n5420.t1 VSS.t25 rhigh l=34u w=0.5u
X9 a_64868_n3050.t1 a_63070_n12306.t7 RESET.t2 VLDO.t0 sg13_lv_pmos ad=0.19p pd=1.38u as=0.34p ps=2.68u w=1u l=0.5u
X10 VLDO.t19 VLDO.t17 VLDO.t18 VLDO.t0 sg13_lv_pmos ad=0.34p pd=2.68u as=0 ps=0 w=1u l=0.5u
X11 a_64868_n3050.t2 RESET.t4 VSS.t15 VLDO.t0 sg13_lv_pmos ad=0.68p pd=4.68u as=0.68p ps=4.68u w=2u l=0.5u
X12 a_64034_n1920.t0 a_64174_n5392.t0 VSS.t23 rhigh l=16.8u w=0.5u
X13 a_64034_n1920.t1 a_64034_n5392.t0 VSS.t21 rhigh l=16.8u w=0.5u
X14 a_66531_1256.t4 a_66395_n630.t1 VSS.t50 rhigh l=9u w=0.5u
X15 a_65785_n2363.t1 a_63070_n12306.t3 VSS.t4 VSS.t0 sg13_lv_nmos ad=95f pd=0.88u as=0.17p ps=1.68u w=0.5u l=0.5u
X16 a_64174_n8960.t1 a_64174_n12406.t0 VSS.t23 rhigh l=16.8u w=0.5u
X17 VSS.t45 VSS.t43 VSS.t44 VSS.t0 sg13_lv_nmos ad=0.17p pd=1.68u as=0 ps=0 w=0.5u l=0.5u
X18 a_63629_1752.t0 a_63629_n5420.t0 VSS.t17 rhigh l=34u w=0.5u
X19 a_63070_1752.t1 a_63070_n5420.t1 VSS.t18 rhigh l=34u w=0.5u
X20 a_63070_n5420.t0 a_63070_n12306.t0 VSS.t18 rhigh l=34u w=0.5u
X21 VSS.t1 a_63070_n12306.t6 a_65785_n2363.t0 VSS.t0 sg13_lv_nmos ad=0.17p pd=1.68u as=95f ps=0.88u w=0.5u l=0.5u
X22 a_64841_n448.t0 a_63770_n5134.t4 a_65812_n248.t0 VSS.t11 sg13_lv_nmos ad=0.34p pd=2.68u as=0.19p ps=1.38u w=1u l=1u
X23 a_63349_n5420.t0 a_63206_n12306.t0 VSS.t25 rhigh l=34u w=0.5u
X24 VLDO.t10 VLDO.t8 VLDO.t9 VLDO.t2 sg13_lv_pmos ad=0.68p pd=4.68u as=0 ps=0 w=2u l=1u
X25 a_64174_n5392.t0 a_64174_n8960.t0 VSS.t23 rhigh l=16.8u w=0.5u
X26 VLDO.t3 a_64841_n448.t7 a_64851_n1595.t0 VLDO.t2 sg13_lv_pmos ad=0.38p pd=2.38u as=0.38p ps=2.38u w=2u l=1u
X27 a_63770_n5134.t1 a_64314_n5392.t0 VSS.t20 rhigh l=16.8u w=0.5u
X28 a_66531_1256.t1 a_66531_1256.t0 VSS.t3 VSS.t2 sg13_lv_nmos ad=0.17p pd=1.68u as=95f ps=0.88u w=0.5u l=1u
X29 a_63206_n5420.t1 a_63206_n12306.t1 VSS.t19 rhigh l=34u w=0.5u
X30 a_63629_n5420.t1 a_63489_n12306.t1 VSS.t17 rhigh l=34u w=0.5u
X31 a_64034_n5392.t0 VSS.t46 VSS.t21 rhigh l=16.8u w=0.5u
X32 VLDO.t16 VLDO.t14 VLDO.t15 VLDO.t0 sg13_lv_pmos ad=0.34p pd=2.68u as=0 ps=0 w=1u l=0.5u
X33 RESET.t1 a_63070_n12306.t10 a_64868_n3050.t0 VLDO.t0 sg13_lv_pmos ad=0.34p pd=2.68u as=0.19p ps=1.38u w=1u l=0.5u
X34 VSS.t33 VSS.t30 VSS.t32 VSS.t31 sg13_lv_nmos ad=0.34p pd=2.68u as=0 ps=0 w=1u l=1u
X35 VLDO.t5 a_64851_n1595.t3 a_64887_n1663.t1 VLDO.t0 sg13_lv_pmos ad=1.36p pd=8.68u as=1.36p ps=8.68u w=4u l=0.8u
X36 a_64174_1752.t1 a_64034_n1694.t1 VSS.t23 rhigh l=16.8u w=0.5u
X37 VLDO.t13 VLDO.t11 VLDO.t12 VLDO.t2 sg13_lv_pmos ad=0.68p pd=4.68u as=0 ps=0 w=2u l=1u
X38 VLDO.t21 a_64034_n1694.t0 VSS.t21 rhigh l=16.8u w=0.5u
X39 VSS.t39 VSS.t37 VSS.t38 VSS.t2 sg13_lv_nmos ad=0.17p pd=1.68u as=0 ps=0 w=0.5u l=1u
X40 VSS.t42 VSS.t40 VSS.t41 VSS.t0 sg13_lv_nmos ad=0.17p pd=1.68u as=0 ps=0 w=0.5u l=0.5u
X41 a_63629_1752.t1 a_63770_n5134.t2 VSS.t49 rhigh l=34u w=0.5u
X42 VLDO.t1 a_63070_n12306.t8 a_64868_n3050.t1 VLDO.t0 sg13_lv_pmos ad=0.19p pd=1.38u as=0.19p ps=1.38u w=1u l=0.5u
X43 a_64314_n5392.t0 a_64314_n8960.t0 VSS.t20 rhigh l=16.8u w=0.5u
X44 a_64314_n8960.t1 a_64174_n12406.t1 VSS.t20 rhigh l=16.8u w=0.5u
X45 VSS.t29 VSS.t26 VSS.t28 VSS.t27 sg13_lv_nmos ad=0.34p pd=2.68u as=0 ps=0 w=1u l=1u
X46 a_64851_n1595.t1 VBGR.t0 a_65812_n248.t1 VSS.t48 sg13_lv_nmos ad=0.19p pd=1.38u as=0.19p ps=1.38u w=1u l=1u
X47 a_64174_1752.t0 a_63770_n5134.t0 VSS.t20 rhigh l=16.8u w=0.5u
X48 a_64851_n1595.t0 a_64841_n448.t6 VLDO.t4 VLDO.t2 sg13_lv_pmos ad=0.38p pd=2.38u as=0.38p ps=2.38u w=2u l=1u
X49 a_65812_n248.t0 VBGR.t1 a_64851_n1595.t1 VSS.t47 sg13_lv_nmos ad=0.19p pd=1.38u as=0.19p ps=1.38u w=1u l=1u
X50 a_65812_n248.t1 a_63770_n5134.t3 a_64841_n448.t1 VSS.t12 sg13_lv_nmos ad=0.19p pd=1.38u as=0.34p ps=2.68u w=1u l=1u
X51 VLDO.t4 a_64841_n448.t4 a_64841_n448.t5 VLDO.t2 sg13_lv_pmos ad=0.38p pd=2.38u as=0.68p ps=4.68u w=2u l=1u
X52 VSS.t9 a_64851_n1595.t2 a_64887_n1663.t0 VSS.t8 sg13_lv_nmos ad=0.68p pd=4.68u as=0.68p ps=4.68u w=2u l=0.8u
X53 VSS.t36 VSS.t34 VSS.t35 VSS.t2 sg13_lv_nmos ad=0.17p pd=1.68u as=0 ps=0 w=0.5u l=1u
X54 a_65812_n248.t2 a_66531_1256.t5 VSS.t6 VSS.t2 sg13_lv_nmos ad=95f pd=0.88u as=95f ps=0.88u w=0.5u l=1u
X55 RESET.t0 a_63070_n12306.t4 a_65785_n2363.t1 VSS.t0 sg13_lv_nmos ad=95f pd=0.88u as=95f ps=0.88u w=0.5u l=0.5u
X56 a_63070_n12306.t2 VSS.t5 cap_cmim l=41.52u w=41.52u
X57 VLDO.t22 a_66395_n630.t0 VSS.t22 rhigh l=9u w=0.5u
X58 VSS.t3 a_66531_1256.t6 a_65812_n248.t2 VSS.t2 sg13_lv_nmos ad=95f pd=0.88u as=95f ps=0.88u w=0.5u l=1u
X59 VSS.t6 a_66531_1256.t2 a_66531_1256.t3 VSS.t2 sg13_lv_nmos ad=95f pd=0.88u as=0.17p ps=1.68u w=0.5u l=1u
X60 a_64887_n1663.t2 a_63070_n12306.t1 VSS.t24 rppd l=7.45u w=2u
C0 a_66531_n544# RESET 0.03044f
C1 RESET VBGR 0.04873f
C2 a_63070_n12220# a_63206_n12220# 2.49092f
C3 a_64314_n12320# a_64174_n12320# 1.09405f
C4 VLDO VBGR 0.11706f
C5 a_63489_n12220# a_63349_n12220# 2.21416f
C6 a_63770_n5048# a_64034_n5280# 0.22917f
C7 a_64034_n1608# a_63770_n5048# 0.24616f
C8 a_64034_n1608# a_64174_n1608# 1.09405f
C9 a_66531_n544# a_66395_n544# 0.65936f
C10 VBGR a_66395_n544# 0.03755f
C11 a_64034_n8752# a_64174_n8752# 1.09405f
C12 VLDO a_63770_n5048# 0.07016f
C13 VLDO a_64174_n1608# 0.18422f
C14 a_63489_n5048# a_63349_n5048# 2.21416f
C15 a_64174_n12320# a_63629_n12220# 0.08665f
C16 a_63770_n5048# a_63629_n5048# 2.15431f
C17 VLDO a_64034_n5280# 0.02315f
C18 VLDO a_63489_n5048# 0.03381f
C19 a_63206_n5048# a_63349_n5048# 2.04384f
C20 a_64034_n8752# a_63629_n12220# 0.12976f
C21 a_64034_n1608# VLDO 0.21409f
C22 a_63206_n5048# a_63070_n5048# 2.49092f
C23 a_64174_n1608# a_64314_n1608# 1.09405f
C24 VLDO a_63206_n5048# 0.01915f
C25 a_63489_n5048# a_63629_n5048# 2.21416f
C26 VLDO a_63349_n5048# 0.0251f
C27 VLDO a_64314_n5280# 0.17995f
C28 a_64174_n5280# a_64034_n5280# 1.09405f
C29 VLDO RESET 1.72985f
C30 VLDO a_63070_n5048# 0.01418f
C31 RESET a_66331_n3582# 0.12946f
C32 a_64174_n5280# a_64314_n5280# 1.09405f
C33 a_64314_n8752# a_64174_n8752# 1.09405f
C34 VLDO a_66331_n3582# 0.11513f
C35 VLDO a_63629_n5048# 0.04704f
C36 VLDO a_64174_n5280# 0.03457f
C37 VLDO a_64314_n1608# 0.43034f
C38 a_63349_n12220# a_63206_n12220# 2.04384f
C39 RESET a_66395_n544# 0.01612f
C40 a_63489_n12220# a_63629_n12220# 2.21416f
C41 VLDO a_66395_n544# 0.05929f
R0 RESET.n1 RESET.t0 36.5435
R1 RESET.n2 RESET.t4 25.1531
R2 RESET.n3 RESET.t5 24.0005
R3 RESET.n1 RESET.n0 19.2841
R4 RESET.n4 RESET.n3 11.2777
R5 RESET.n2 RESET.n1 9.0005
R6 RESET.n0 RESET.t1 7.51574
R7 RESET.n0 RESET.t2 7.39887
R8 RESET.n4 RESET.t3 6.7343
R9 RESET RESET.n4 5.21121
R10 RESET.n3 RESET.n2 1.30762
R11 VBGR.n0 VBGR.t0 12.6532
R12 VBGR.n0 VBGR.t1 12.046
R13 VBGR VBGR.n0 2.7747
R14 VLDO.n110 VLDO.t22 35.8855
R15 VLDO.n3 VLDO.t21 29.8319
R16 VLDO.n0 VLDO.t20 26.7838
R17 VLDO.n0 VLDO.t1 25.418
R18 VLDO.n37 VLDO.t9 17.0005
R19 VLDO.t9 VLDO.n36 17.0005
R20 VLDO.t9 VLDO.n35 17.0005
R21 VLDO.t9 VLDO.n34 17.0005
R22 VLDO.t9 VLDO.n33 17.0005
R23 VLDO.t9 VLDO.n32 17.0005
R24 VLDO.t15 VLDO.n63 17.0005
R25 VLDO.t15 VLDO.n58 17.0005
R26 VLDO.n64 VLDO.t15 17.0005
R27 VLDO.n71 VLDO.t19 17.0005
R28 VLDO.t19 VLDO.n70 17.0005
R29 VLDO.t19 VLDO.n68 17.0005
R30 VLDO.n54 VLDO.n53 17.0005
R31 VLDO.n62 VLDO.n54 17.0005
R32 VLDO.n59 VLDO.n54 17.0005
R33 VLDO.n57 VLDO.n54 17.0005
R34 VLDO.n72 VLDO.n54 17.0005
R35 VLDO.n56 VLDO.n54 17.0005
R36 VLDO.n69 VLDO.n54 17.0005
R37 VLDO.n103 VLDO.n29 17.0005
R38 VLDO.n103 VLDO.n28 17.0005
R39 VLDO.n103 VLDO.n27 17.0005
R40 VLDO.n103 VLDO.n26 17.0005
R41 VLDO.n103 VLDO.n25 17.0005
R42 VLDO.t13 VLDO.n100 17.0005
R43 VLDO.t13 VLDO.n47 17.0005
R44 VLDO.t13 VLDO.n46 17.0005
R45 VLDO.t13 VLDO.n43 17.0005
R46 VLDO.n101 VLDO.t13 17.0005
R47 VLDO.t13 VLDO.n41 17.0005
R48 VLDO.n50 VLDO.n49 17.0005
R49 VLDO.n49 VLDO.n48 17.0005
R50 VLDO.n45 VLDO.n44 17.0005
R51 VLDO.n44 VLDO.n42 17.0005
R52 VLDO.n103 VLDO.n102 17.0005
R53 VLDO.n60 VLDO.t14 15.0005
R54 VLDO.n55 VLDO.t17 15.0005
R55 VLDO.n1 VLDO.t5 14.2508
R56 VLDO.t2 VLDO.n22 8.501
R57 VLDO.t2 VLDO.n21 8.501
R58 VLDO.t2 VLDO.n20 8.501
R59 VLDO.t2 VLDO.n23 8.501
R60 VLDO.t2 VLDO.n9 8.501
R61 VLDO.t2 VLDO.n10 8.501
R62 VLDO.t2 VLDO.n11 8.501
R63 VLDO.t2 VLDO.n12 8.501
R64 VLDO.t2 VLDO.n13 8.501
R65 VLDO.t2 VLDO.n14 8.501
R66 VLDO.t2 VLDO.n15 8.501
R67 VLDO.t2 VLDO.n16 8.501
R68 VLDO.t2 VLDO.n18 8.501
R69 VLDO.t2 VLDO.n7 8.501
R70 VLDO.n105 VLDO.t2 8.501
R71 VLDO.n107 VLDO.n106 8.49088
R72 VLDO.n96 VLDO.n79 8.48362
R73 VLDO.n99 VLDO.n98 8.46995
R74 VLDO.n95 VLDO.n80 8.46995
R75 VLDO.n94 VLDO.n81 8.46995
R76 VLDO.n93 VLDO.n82 8.46995
R77 VLDO.n92 VLDO.n83 8.46995
R78 VLDO.n91 VLDO.n84 8.46995
R79 VLDO.n90 VLDO.n85 8.46995
R80 VLDO.n89 VLDO.n86 8.46995
R81 VLDO.n88 VLDO.n87 8.46995
R82 VLDO.n17 VLDO.n6 8.46995
R83 VLDO.n55 VLDO.t18 6.33335
R84 VLDO.n60 VLDO.t16 6.32648
R85 VLDO.n3 VLDO.n2 6.09881
R86 VLDO.n67 VLDO.n54 5.61281
R87 VLDO.n30 VLDO.t8 4.89895
R88 VLDO.n39 VLDO.t11 4.89895
R89 VLDO.n2 VLDO.t4 4.28167
R90 VLDO.n2 VLDO.t3 4.24729
R91 VLDO.n103 VLDO.n38 4.18423
R92 VLDO.n39 VLDO.t12 3.84915
R93 VLDO.n30 VLDO.t10 3.8488
R94 VLDO.n4 VLDO.n3 3.0005
R95 VLDO.n109 VLDO.n108 3.0005
R96 VLDO.n8 VLDO.n5 1.9849
R97 VLDO.n66 VLDO.t0 1.72252
R98 VLDO.n52 VLDO.n51 1.70109
R99 VLDO.n77 VLDO.n76 1.447
R100 VLDO.n78 VLDO.n77 1.44096
R101 VLDO.n4 VLDO.n1 1.30539
R102 VLDO.n40 VLDO.n24 1.27023
R103 VLDO.n31 VLDO.n24 1.26445
R104 VLDO.n74 VLDO.n73 1.20075
R105 VLDO.n65 VLDO.n64 1.15826
R106 VLDO.n66 VLDO.n65 1.11642
R107 VLDO.n75 VLDO.n74 1.06828
R108 VLDO.n110 VLDO.n109 0.708944
R109 VLDO.n38 VLDO.n5 0.676118
R110 VLDO.n31 VLDO.n30 0.568704
R111 VLDO.n40 VLDO.n39 0.568357
R112 VLDO.n76 VLDO.n51 0.483385
R113 VLDO.n78 VLDO.n51 0.470285
R114 VLDO.n1 VLDO.n0 0.469833
R115 VLDO.n61 VLDO.n60 0.430188
R116 VLDO.n73 VLDO.n55 0.423312
R117 VLDO.n109 VLDO.n4 0.395167
R118 VLDO.n52 VLDO.n19 0.355167
R119 VLDO.n89 VLDO.n88 0.345711
R120 VLDO.n74 VLDO.n54 0.340731
R121 VLDO.n108 VLDO.n5 0.336553
R122 VLDO.t2 VLDO.n104 0.328367
R123 VLDO.n65 VLDO.n54 0.286754
R124 VLDO.t0 VLDO.n54 0.274694
R125 VLDO.n97 VLDO.n78 0.257167
R126 VLDO.n76 VLDO.n75 0.257167
R127 VLDO.n88 VLDO.n6 0.250378
R128 VLDO.n90 VLDO.n89 0.250378
R129 VLDO.n91 VLDO.n90 0.250378
R130 VLDO.n92 VLDO.n91 0.250378
R131 VLDO.n93 VLDO.n92 0.250378
R132 VLDO.n94 VLDO.n93 0.250378
R133 VLDO.n95 VLDO.n94 0.250378
R134 VLDO.n67 VLDO.n66 0.250092
R135 VLDO.n96 VLDO.n95 0.223034
R136 VLDO.n107 VLDO.n6 0.208519
R137 VLDO.n38 VLDO.n37 0.204676
R138 VLDO.n99 VLDO.n97 0.187772
R139 VLDO.n68 VLDO.n67 0.159476
R140 VLDO VLDO.n110 0.1365
R141 VLDO.n103 VLDO.n24 0.133946
R142 VLDO.n75 VLDO.n53 0.125167
R143 VLDO.n61 VLDO.n53 0.123333
R144 VLDO.n77 VLDO.n52 0.102123
R145 VLDO.n100 VLDO.n99 0.0947826
R146 VLDO.n108 VLDO.n107 0.0456331
R147 VLDO.n97 VLDO.n96 0.0357621
R148 VLDO.n102 VLDO.n101 0.0231804
R149 VLDO.n43 VLDO.n42 0.0231804
R150 VLDO.n33 VLDO.n25 0.0227222
R151 VLDO.n34 VLDO.n26 0.0227222
R152 VLDO.n45 VLDO.n43 0.0220464
R153 VLDO.n48 VLDO.n46 0.0220464
R154 VLDO.n50 VLDO.n47 0.0220464
R155 VLDO.n34 VLDO.n27 0.0216111
R156 VLDO.n35 VLDO.n28 0.0216111
R157 VLDO.n36 VLDO.n29 0.0216111
R158 VLDO.n63 VLDO.n59 0.0191522
R159 VLDO.n71 VLDO.n56 0.0189914
R160 VLDO.n58 VLDO.n57 0.0181957
R161 VLDO.n70 VLDO.n69 0.0180431
R162 VLDO.n41 VLDO.n40 0.0175103
R163 VLDO.n46 VLDO.n45 0.0175103
R164 VLDO.n48 VLDO.n47 0.0175103
R165 VLDO.n100 VLDO.n50 0.0175103
R166 VLDO.n32 VLDO.n31 0.0171667
R167 VLDO.n35 VLDO.n27 0.0171667
R168 VLDO.n36 VLDO.n28 0.0171667
R169 VLDO.n37 VLDO.n29 0.0171667
R170 VLDO.n102 VLDO.n41 0.0163763
R171 VLDO.n101 VLDO.n42 0.0163763
R172 VLDO.n64 VLDO.n57 0.0162826
R173 VLDO.n69 VLDO.n68 0.0161466
R174 VLDO.n32 VLDO.n25 0.0160556
R175 VLDO.n33 VLDO.n26 0.0160556
R176 VLDO.n59 VLDO.n58 0.0153261
R177 VLDO.n70 VLDO.n56 0.0151983
R178 VLDO.n63 VLDO.n62 0.0143696
R179 VLDO.n72 VLDO.n71 0.01425
R180 VLDO.n104 VLDO.n8 0.00151926
R181 VLDO.n104 VLDO.n103 0.00148072
R182 VLDO.n106 VLDO.n105 0.001
R183 VLDO.n17 VLDO.n7 0.001
R184 VLDO.n87 VLDO.n18 0.001
R185 VLDO.n86 VLDO.n16 0.001
R186 VLDO.n85 VLDO.n15 0.001
R187 VLDO.n84 VLDO.n14 0.001
R188 VLDO.n83 VLDO.n13 0.001
R189 VLDO.n82 VLDO.n12 0.001
R190 VLDO.n81 VLDO.n11 0.001
R191 VLDO.n80 VLDO.n10 0.001
R192 VLDO.n79 VLDO.n9 0.001
R193 VLDO.t2 VLDO.n19 0.001
R194 VLDO.t0 VLDO.n19 0.001
R195 VLDO.n103 VLDO.n20 0.001
R196 VLDO.n44 VLDO.n21 0.001
R197 VLDO.n49 VLDO.n22 0.001
R198 VLDO.n98 VLDO.n23 0.001
R199 VLDO.n49 VLDO.n21 0.001
R200 VLDO.n44 VLDO.n20 0.001
R201 VLDO.n79 VLDO.n23 0.001
R202 VLDO.n98 VLDO.n22 0.001
R203 VLDO.n80 VLDO.n9 0.001
R204 VLDO.n81 VLDO.n10 0.001
R205 VLDO.n82 VLDO.n11 0.001
R206 VLDO.n83 VLDO.n12 0.001
R207 VLDO.n84 VLDO.n13 0.001
R208 VLDO.n85 VLDO.n14 0.001
R209 VLDO.n86 VLDO.n15 0.001
R210 VLDO.n87 VLDO.n16 0.001
R211 VLDO.n18 VLDO.n17 0.001
R212 VLDO.n106 VLDO.n7 0.001
R213 VLDO.n105 VLDO.n8 0.001
R214 VLDO.n62 VLDO.n61 0.000978261
R215 VLDO.n73 VLDO.n72 0.000974138
R216 VSS.t20 VSS.n80 7707.19
R217 VSS.n49 VSS.n10 3244.7
R218 VSS.n81 VSS.t20 3075.69
R219 VSS.n11 VSS.n10 2983.2
R220 VSS.t31 VSS.n49 2589.04
R221 VSS.n70 VSS.t27 2512.52
R222 VSS.t12 VSS.n73 2352.74
R223 VSS.n73 VSS.t31 1530.82
R224 VSS.t47 VSS.n75 318.423
R225 VSS.t11 VSS.n76 314.308
R226 VSS.n74 VSS.t12 313.159
R227 VSS.n79 VSS.t27 302.159
R228 VSS.n75 VSS.t48 273.043
R229 VSS.n77 VSS.t27 200.718
R230 VSS.t48 VSS.n74 145.51
R231 VSS.t12 VSS.n48 145.016
R232 VSS.n11 VSS.t13 116.918
R233 VSS.t31 VSS.n48 110.371
R234 VSS.n76 VSS.t47 107.605
R235 VSS.n77 VSS.t11 81.4899
R236 VSS.t21 VSS.t49 55.3387
R237 VSS.n166 VSS.n7 41.0221
R238 VSS.n78 VSS.n75 38.7551
R239 VSS.n167 VSS.n165 35.2318
R240 VSS.t50 VSS.n7 34.6158
R241 VSS.t5 VSS.t46 34.3783
R242 VSS.t25 VSS.t19 29.9753
R243 VSS.t49 VSS.t17 29.5561
R244 VSS.t20 VSS.t23 29.3465
R245 VSS.t23 VSS.t21 29.3465
R246 VSS.t17 VSS.t16 29.3465
R247 VSS.t16 VSS.t25 29.3465
R248 VSS.t22 VSS.n9 29.3093
R249 VSS.t19 VSS.t18 28.508
R250 VSS.n89 VSS.n88 27.2247
R251 VSS.n165 VSS.n23 27.2247
R252 VSS.n86 VSS.t0 26.6909
R253 VSS.n163 VSS.n81 26.1571
R254 VSS.n162 VSS.n31 26.1571
R255 VSS.n85 VSS.n30 26.1571
R256 VSS.t2 VSS.n86 25.0895
R257 VSS.n72 VSS.n9 20.2343
R258 VSS.n2 VSS.t3 19.4893
R259 VSS.n19 VSS.t24 19.2176
R260 VSS.n78 VSS.n74 19.1725
R261 VSS.t14 VSS.n107 18.1914
R262 VSS.n109 VSS.n108 18.0784
R263 VSS.n26 VSS.t36 17.6601
R264 VSS.n32 VSS.t38 17.6597
R265 VSS.n127 VSS.t4 17.5986
R266 VSS.n116 VSS.t1 17.5986
R267 VSS.n91 VSS.t42 17.5928
R268 VSS.n100 VSS.t44 17.5861
R269 VSS.t24 VSS.n16 17.0824
R270 VSS.n101 VSS.t45 17.0005
R271 VSS.n92 VSS.t41 17.0005
R272 VSS.n56 VSS.t9 17.0005
R273 VSS.t9 VSS.n55 17.0005
R274 VSS.t9 VSS.n54 17.0005
R275 VSS.t9 VSS.n53 17.0005
R276 VSS.t9 VSS.n52 17.0005
R277 VSS.t9 VSS.n51 17.0005
R278 VSS.n66 VSS.t28 17.0005
R279 VSS.t28 VSS.n65 17.0005
R280 VSS.t28 VSS.n64 17.0005
R281 VSS.n45 VSS.t33 17.0005
R282 VSS.t33 VSS.n44 17.0005
R283 VSS.t33 VSS.n43 17.0005
R284 VSS.n2 VSS.t6 17.0005
R285 VSS.n33 VSS.t39 17.0005
R286 VSS.n69 VSS.n61 17.0005
R287 VSS.n78 VSS.n41 17.0005
R288 VSS.n78 VSS.n38 17.0005
R289 VSS.n69 VSS.n62 17.0005
R290 VSS.n69 VSS.n60 17.0005
R291 VSS.n69 VSS.n68 17.0005
R292 VSS.n161 VSS.n89 17.0005
R293 VSS.n161 VSS.n86 17.0005
R294 VSS.n161 VSS.n85 17.0005
R295 VSS.n162 VSS.n161 17.0005
R296 VSS.n118 VSS.n117 17.0005
R297 VSS.n119 VSS.n118 17.0005
R298 VSS.n89 VSS.n82 17.0005
R299 VSS.n86 VSS.n82 17.0005
R300 VSS.n85 VSS.n82 17.0005
R301 VSS.n162 VSS.n82 17.0005
R302 VSS.n168 VSS.n14 17.0005
R303 VSS.n168 VSS.n15 17.0005
R304 VSS.n168 VSS.n17 17.0005
R305 VSS.n168 VSS.n18 17.0005
R306 VSS.n168 VSS.n20 17.0005
R307 VSS.n168 VSS.n6 17.0005
R308 VSS.n165 VSS.n1 17.0005
R309 VSS.n30 VSS.n1 17.0005
R310 VSS.n164 VSS.n30 17.0005
R311 VSS.n27 VSS.t35 17.0005
R312 VSS.n165 VSS.n164 17.0005
R313 VSS.n80 VSS.n79 16.4447
R314 VSS.t8 VSS.t22 16.0147
R315 VSS.n100 VSS.t43 15.0005
R316 VSS.n91 VSS.t40 15.0005
R317 VSS.n171 VSS.n3 14.3209
R318 VSS.n16 VSS.t8 12.8119
R319 VSS.n6 VSS.n5 12.7018
R320 VSS.n106 VSS.t15 10.3047
R321 VSS.n163 VSS.n162 10.1428
R322 VSS.n85 VSS.n31 10.1428
R323 VSS.t0 VSS.n30 10.1428
R324 VSS.n89 VSS.n87 9.07523
R325 VSS.n88 VSS.n23 9.07523
R326 VSS.n113 VSS.n81 8.501
R327 VSS.n110 VSS.n81 8.501
R328 VSS.n105 VSS.n81 8.501
R329 VSS.n122 VSS.n81 8.501
R330 VSS.n124 VSS.n81 8.501
R331 VSS.n103 VSS.n81 8.501
R332 VSS.n130 VSS.n81 8.501
R333 VSS.n132 VSS.n81 8.501
R334 VSS.n141 VSS.n23 8.501
R335 VSS.n143 VSS.n23 8.501
R336 VSS.n97 VSS.n23 8.501
R337 VSS.n148 VSS.n23 8.501
R338 VSS.n150 VSS.n23 8.501
R339 VSS.n95 VSS.n23 8.501
R340 VSS.n155 VSS.n23 8.501
R341 VSS.n157 VSS.n23 8.501
R342 VSS.n88 VSS.n24 8.501
R343 VSS.n87 VSS.n25 8.501
R344 VSS.n168 VSS.n16 8.5005
R345 VSS.n168 VSS.n19 8.5005
R346 VSS.n164 VSS.n31 8.5005
R347 VSS.n168 VSS.n4 8.48453
R348 VSS.n169 VSS.n168 8.47294
R349 VSS.n35 VSS.n1 8.47086
R350 VSS.n78 VSS.n40 8.46995
R351 VSS.n112 VSS.n111 8.46995
R352 VSS.n115 VSS.n114 8.46995
R353 VSS.n121 VSS.n120 8.46995
R354 VSS.n126 VSS.n125 8.46995
R355 VSS.n129 VSS.n128 8.46995
R356 VSS.n131 VSS.n102 8.46995
R357 VSS.n135 VSS.n134 8.46995
R358 VSS.n140 VSS.n139 8.46995
R359 VSS.n142 VSS.n98 8.46995
R360 VSS.n145 VSS.n144 8.46995
R361 VSS.n147 VSS.n146 8.46995
R362 VSS.n152 VSS.n151 8.46995
R363 VSS.n154 VSS.n153 8.46995
R364 VSS.n156 VSS.n94 8.46995
R365 VSS.n159 VSS.n158 8.46995
R366 VSS.n3 VSS.n1 8.46995
R367 VSS.n164 VSS.n0 8.46995
R368 VSS.n71 VSS.n50 8.46995
R369 VSS.n123 VSS.n104 8.44635
R370 VSS.n149 VSS.n96 8.44635
R371 VSS.n19 VSS.t50 7.47381
R372 VSS.n42 VSS.t32 6.49937
R373 VSS.n63 VSS.t29 6.49902
R374 VSS.n99 VSS.n23 5.66778
R375 VSS.n133 VSS.n81 5.66778
R376 VSS.n49 VSS.n39 5.66767
R377 VSS.n84 VSS.n81 5.66767
R378 VSS.n90 VSS.n23 5.66767
R379 VSS.n138 VSS.n82 5.62486
R380 VSS.n168 VSS.n22 5.61093
R381 VSS.n26 VSS.t34 4.92297
R382 VSS.n32 VSS.t37 4.92297
R383 VSS.n63 VSS.t26 4.89895
R384 VSS.n42 VSS.t30 4.89895
R385 VSS.n78 VSS.n77 4.54317
R386 VSS.n80 VSS.n37 4.251
R387 VSS.n161 VSS.n160 4.18441
R388 VSS.n161 VSS.n83 4.18423
R389 VSS.n73 VSS.n72 3.73715
R390 VSS.n136 VSS.n82 3.32604
R391 VSS.n168 VSS.n167 2.42907
R392 VSS.n87 VSS.t2 2.13573
R393 VSS.n78 VSS.n76 2.1182
R394 VSS.n168 VSS.n13 1.97226
R395 VSS.n168 VSS.n8 1.70617
R396 VSS.n12 VSS.n11 1.43304
R397 VSS.n168 VSS.n7 1.35688
R398 VSS.n68 VSS.n47 1.34108
R399 VSS.n61 VSS.n59 1.33043
R400 VSS.n59 VSS.n58 1.30032
R401 VSS.n47 VSS.n46 1.25387
R402 VSS.n172 VSS.n1 1.19748
R403 VSS.n36 VSS.n35 1.07469
R404 VSS.n167 VSS.n166 1.06812
R405 VSS.n174 VSS.n173 1.05605
R406 VSS.n108 VSS.n106 1.039
R407 VSS.n107 VSS.n36 1.03414
R408 VSS.n175 VSS.n174 1.00516
R409 VSS.n172 VSS.n171 0.869622
R410 VSS.n107 VSS.n29 0.862111
R411 VSS.n164 VSS.n29 0.800525
R412 VSS.n29 VSS.n28 0.77823
R413 VSS.n173 VSS.n172 0.663778
R414 VSS.n21 VSS.n8 0.62392
R415 VSS.n173 VSS.n2 0.612375
R416 VSS.n67 VSS.n63 0.596204
R417 VSS.n164 VSS.n36 0.596173
R418 VSS.n46 VSS.n42 0.595857
R419 VSS.n174 VSS.n1 0.591688
R420 VSS.n72 VSS.n71 0.548887
R421 VSS.n164 VSS.n163 0.548887
R422 VSS.n166 VSS.n1 0.548887
R423 VSS.n13 VSS.n12 0.515305
R424 VSS.n58 VSS.n57 0.514434
R425 VSS.n12 VSS.n8 0.497176
R426 VSS.n33 VSS.n32 0.484755
R427 VSS.n27 VSS.n26 0.484411
R428 VSS.n101 VSS.n100 0.420917
R429 VSS.n92 VSS.n91 0.41425
R430 VSS.n136 VSS.n135 0.373698
R431 VSS VSS.n175 0.368278
R432 VSS.n171 VSS.n170 0.339035
R433 VSS.n57 VSS.n13 0.337229
R434 VSS.n111 VSS.n83 0.333448
R435 VSS.n160 VSS.n159 0.333068
R436 VSS.n120 VSS.n104 0.297565
R437 VSS.n126 VSS.n104 0.297565
R438 VSS.n152 VSS.n96 0.297565
R439 VSS.n146 VSS.n96 0.297565
R440 VSS.n139 VSS.n138 0.276441
R441 VSS.n115 VSS.n111 0.250378
R442 VSS.n128 VSS.n126 0.250378
R443 VSS.n135 VSS.n102 0.250378
R444 VSS.n159 VSS.n94 0.250378
R445 VSS.n153 VSS.n94 0.250378
R446 VSS.n153 VSS.n152 0.250378
R447 VSS.n146 VSS.n145 0.250378
R448 VSS.n145 VSS.n98 0.250378
R449 VSS.n139 VSS.n98 0.250378
R450 VSS.n50 VSS.n40 0.250378
R451 VSS.n169 VSS.n5 0.235939
R452 VSS.n138 VSS.n137 0.231691
R453 VSS.n168 VSS.n9 0.222912
R454 VSS.n93 VSS.n83 0.206343
R455 VSS.n22 VSS.n21 0.20173
R456 VSS.n71 VSS.n59 0.188419
R457 VSS.n120 VSS.n119 0.187772
R458 VSS.n108 VSS.t14 0.186574
R459 VSS.n170 VSS.n169 0.186434
R460 VSS.n22 VSS.n5 0.178631
R461 VSS.n160 VSS.n93 0.173728
R462 VSS.n137 VSS.n136 0.165114
R463 VSS.n78 VSS.n47 0.160238
R464 VSS.n116 VSS.n115 0.151106
R465 VSS.n127 VSS.n102 0.151106
R466 VSS.n106 VSS.t5 0.133892
R467 VSS.n43 VSS.n40 0.131397
R468 VSS.n34 VSS.n33 0.12248
R469 VSS.n137 VSS.n101 0.1215
R470 VSS.n93 VSS.n92 0.1215
R471 VSS.n28 VSS.n27 0.118124
R472 VSS.n51 VSS.n4 0.106838
R473 VSS.n28 VSS.n0 0.101606
R474 VSS.n34 VSS.n3 0.101606
R475 VSS.n128 VSS.n127 0.0997723
R476 VSS.n64 VSS.n61 0.0698772
R477 VSS.n175 VSS.n0 0.064939
R478 VSS.n119 VSS.n109 0.0646667
R479 VSS.n58 VSS.n50 0.0631056
R480 VSS.n35 VSS.n34 0.0612855
R481 VSS.n117 VSS.n109 0.061
R482 VSS.n52 VSS.n20 0.0421993
R483 VSS.n53 VSS.n18 0.0421993
R484 VSS.n54 VSS.n17 0.0421993
R485 VSS.n117 VSS.n116 0.0371667
R486 VSS.n64 VSS.n62 0.0352368
R487 VSS.n170 VSS.n4 0.0339361
R488 VSS.n65 VSS.n60 0.0337895
R489 VSS.n43 VSS.n38 0.0335
R490 VSS.n44 VSS.n41 0.032125
R491 VSS.n54 VSS.n15 0.0278203
R492 VSS.n55 VSS.n14 0.0278203
R493 VSS.n68 VSS.n67 0.0261667
R494 VSS.n57 VSS.n56 0.0257353
R495 VSS.n67 VSS.n66 0.0222105
R496 VSS.n55 VSS.n15 0.0220686
R497 VSS.n56 VSS.n14 0.0220686
R498 VSS.n46 VSS.n45 0.021125
R499 VSS.n66 VSS.n60 0.0178684
R500 VSS.n45 VSS.n41 0.017
R501 VSS.n65 VSS.n62 0.0164211
R502 VSS.n44 VSS.n38 0.015625
R503 VSS.n51 VSS.n20 0.00768954
R504 VSS.n52 VSS.n18 0.00768954
R505 VSS.n53 VSS.n17 0.00768954
R506 VSS.n21 VSS.n6 0.00233333
R507 VSS.n78 VSS.n37 0.00175
R508 VSS.n134 VSS.n133 0.00166667
R509 VSS.n140 VSS.n99 0.00166667
R510 VSS.n70 VSS.n69 0.00166667
R511 VSS.n79 VSS.n78 0.00159733
R512 VSS.n71 VSS.n70 0.00133332
R513 VSS.n133 VSS.n82 0.00133332
R514 VSS.n99 VSS.n82 0.00133332
R515 VSS.n69 VSS.n37 0.00124998
R516 VSS.n78 VSS.n48 0.00101719
R517 VSS.n168 VSS.n10 0.001
R518 VSS.n25 VSS.n1 0.001
R519 VSS.n112 VSS.n84 0.001
R520 VSS.n113 VSS.n112 0.001
R521 VSS.n114 VSS.n110 0.001
R522 VSS.n118 VSS.n105 0.001
R523 VSS.n122 VSS.n121 0.001
R524 VSS.n124 VSS.n123 0.001
R525 VSS.n125 VSS.n103 0.001
R526 VSS.n130 VSS.n129 0.001
R527 VSS.n132 VSS.n131 0.001
R528 VSS.n158 VSS.n90 0.001
R529 VSS.n158 VSS.n157 0.001
R530 VSS.n156 VSS.n155 0.001
R531 VSS.n154 VSS.n95 0.001
R532 VSS.n151 VSS.n150 0.001
R533 VSS.n149 VSS.n148 0.001
R534 VSS.n147 VSS.n97 0.001
R535 VSS.n144 VSS.n143 0.001
R536 VSS.n142 VSS.n141 0.001
R537 VSS.n78 VSS.n39 0.001
R538 VSS.n71 VSS.n39 0.001
R539 VSS.n161 VSS.n90 0.001
R540 VSS.n161 VSS.n84 0.001
R541 VSS.n114 VSS.n113 0.001
R542 VSS.n118 VSS.n110 0.001
R543 VSS.n121 VSS.n105 0.001
R544 VSS.n123 VSS.n122 0.001
R545 VSS.n125 VSS.n124 0.001
R546 VSS.n129 VSS.n103 0.001
R547 VSS.n131 VSS.n130 0.001
R548 VSS.n134 VSS.n132 0.001
R549 VSS.n141 VSS.n140 0.001
R550 VSS.n143 VSS.n142 0.001
R551 VSS.n144 VSS.n97 0.001
R552 VSS.n148 VSS.n147 0.001
R553 VSS.n150 VSS.n149 0.001
R554 VSS.n151 VSS.n95 0.001
R555 VSS.n155 VSS.n154 0.001
R556 VSS.n157 VSS.n156 0.001
R557 VSS.n24 VSS.n1 0.001
R558 VSS.n164 VSS.n25 0.001
R559 VSS.n164 VSS.n24 0.001
R560 a_64174_n12406.t0 a_64174_n12406.t1 30.2407
R561 a_64314_n8960.t0 a_64314_n8960.t1 30.1153
R562 a_64868_n3050.n0 a_64868_n3050.t1 5.66739
R563 a_64868_n3050.t0 a_64868_n3050.n0 7.55644
R564 a_64868_n3050.n0 a_64868_n3050.t2 17.8453
R565 a_65785_n2363.t0 a_65785_n2363.n0 17.0005
R566 a_65785_n2363.n0 a_65785_n2363.t2 34.7447
R567 a_65785_n2363.n0 a_65785_n2363.t1 18.7608
R568 a_64174_n8960.t0 a_64174_n8960.t1 30.1153
R569 a_63489_n12306.t0 a_63489_n12306.t1 30.2967
R570 a_63206_n12306.t0 a_63206_n12306.t1 30.303
R571 a_63070_n12306.t0 a_63070_n12306.n0 58.0865
R572 a_63070_n12306.n0 a_63070_n12306.n1 0.0934577
R573 a_63070_n12306.n1 a_63070_n12306.n8 5.0663
R574 a_63070_n12306.n8 a_63070_n12306.n2 11.1626
R575 a_63070_n12306.n8 a_63070_n12306.n5 18.6666
R576 a_63070_n12306.n5 a_63070_n12306.t6 15.0005
R577 a_63070_n12306.n6 a_63070_n12306.t5 15.0005
R578 a_63070_n12306.n7 a_63070_n12306.t4 15.0005
R579 a_63070_n12306.n7 a_63070_n12306.t3 15.6055
R580 a_63070_n12306.n6 a_63070_n12306.n7 0.6055
R581 a_63070_n12306.n5 a_63070_n12306.n6 0.636765
R582 a_63070_n12306.n3 a_63070_n12306.n4 0.3877
R583 a_63070_n12306.n2 a_63070_n12306.n3 0.3833
R584 a_63070_n12306.n4 a_63070_n12306.t7 24.3877
R585 a_63070_n12306.n4 a_63070_n12306.t8 24.0005
R586 a_63070_n12306.n3 a_63070_n12306.t9 24.0005
R587 a_63070_n12306.n2 a_63070_n12306.t10 24.0005
R588 a_63070_n12306.n1 a_63070_n12306.t2 13.4288
R589 a_63070_n12306.n0 a_63070_n12306.t1 7.00783
R590 a_64034_n1920.t0 a_64034_n1920.t1 30.2967
R591 a_64887_n1663.t0 a_64887_n1663.n0 5.18001
R592 a_64887_n1663.n0 a_64887_n1663.t2 4.41667
R593 a_64887_n1663.n0 a_64887_n1663.t1 8.70133
R594 a_66531_1256.n0 a_66531_1256.t0 4.89895
R595 a_66531_1256.n1 a_66531_1256.t6 4.89895
R596 a_66531_1256.n2 a_66531_1256.t5 4.89895
R597 a_66531_1256.n3 a_66531_1256.t2 4.89895
R598 a_66531_1256.t3 a_66531_1256.n3 18.0015
R599 a_66531_1256.n3 a_66531_1256.n2 0.944061
R600 a_66531_1256.n2 a_66531_1256.n1 0.944061
R601 a_66531_1256.n1 a_66531_1256.n0 0.944061
R602 a_66531_1256.n4 a_66531_1256.t1 17.0005
R603 a_66531_1256.n4 a_66531_1256.t4 43.946
R604 a_66531_1256.n0 a_66531_1256.n4 0.960907
R605 a_66395_n630.t0 a_66395_n630.t1 30.2882
R606 a_65812_n248.t2 a_65812_n248.n0 37.6376
R607 a_65812_n248.n0 a_65812_n248.t0 5.63501
R608 a_65812_n248.n0 a_65812_n248.t1 8.33855
R609 a_63770_n5134.t0 a_63770_n5134.n0 15.0005
R610 a_63770_n5134.n0 a_63770_n5134.n1 9.0005
R611 a_63770_n5134.n0 a_63770_n5134.t1 15.2396
R612 a_63770_n5134.n1 a_63770_n5134.n2 23.0706
R613 a_63770_n5134.n2 a_63770_n5134.t3 12.045
R614 a_63770_n5134.n2 a_63770_n5134.t4 13.8622
R615 a_63770_n5134.n1 a_63770_n5134.t2 30.2866
R616 a_64851_n1595.t1 a_64851_n1595.n0 10.2201
R617 a_64851_n1595.n0 a_64851_n1595.n1 5.48359
R618 a_64851_n1595.n1 a_64851_n1595.t2 33.4684
R619 a_64851_n1595.n1 a_64851_n1595.t3 33.2484
R620 a_64851_n1595.n0 a_64851_n1595.t0 12.8248
R621 a_64841_n448.t1 a_64841_n448.n0 10.1397
R622 a_64841_n448.n0 a_64841_n448.t0 5.6692
R623 a_64841_n448.n0 a_64841_n448.n1 14.5716
R624 a_64841_n448.n1 a_64841_n448.t3 2.80426
R625 a_64841_n448.n2 a_64841_n448.t2 4.89895
R626 a_64841_n448.n2 a_64841_n448.n3 0.944408
R627 a_64841_n448.n3 a_64841_n448.t7 4.89895
R628 a_64841_n448.n4 a_64841_n448.t6 4.89895
R629 a_64841_n448.n5 a_64841_n448.t4 4.89895
R630 a_64841_n448.n5 a_64841_n448.t5 3.8763
R631 a_64841_n448.n4 a_64841_n448.n5 0.944061
R632 a_64841_n448.n3 a_64841_n448.n4 0.944061
R633 a_64841_n448.n1 a_64841_n448.n2 0.970606
R634 a_64174_1752.t0 a_64174_1752.t1 30.2967
R635 a_64034_n1694.t0 a_64034_n1694.t1 30.2967
R636 a_63629_n5420.t0 a_63629_n5420.t1 30.3114
R637 a_63629_1752.t0 a_63629_1752.t1 30.2988
R638 a_63489_n5420.t0 a_63489_n5420.t1 30.3114
R639 a_63349_n5420.t0 a_63349_n5420.t1 30.3114
R640 a_63349_1752.t0 a_63349_1752.t1 30.2967
R641 a_63206_n5420.t0 a_63206_n5420.t1 30.3114
R642 a_63070_n5420.t0 a_63070_n5420.t1 30.3114
R643 a_63070_1752.t0 a_63070_1752.t1 30.2882
C42 RESET VSS 1.10011p
C43 VBGR VSS 1.62656f
C44 VLDO VSS 4.05805f
C45 a_64314_n12320# VSS 1.67864f
C46 a_64174_n12320# VSS 1.55422f
C47 a_64314_n8752# VSS 1.67935f
C48 a_66331_n3582# VSS 2.12818f
C49 a_64314_n5280# VSS 1.55949f
C50 a_64174_n8752# VSS 1.08631f
C51 a_64174_n5280# VSS 1.06622f
C52 a_64034_n8752# VSS 1.55577f
C53 a_63629_n12220# VSS 3.07272f
C54 a_63489_n12220# VSS 2.16814f
C55 a_63349_n12220# VSS 2.18676f
C56 a_63206_n12220# VSS 2.15305f
C57 a_63070_n12220# VSS 3.30439f
C58 a_64034_n5280# VSS 1.37599f
C59 a_66531_n544# VSS 1.04582f
C60 a_66395_n544# VSS 1.00944f
C61 a_64314_n1608# VSS 1.48896f
C62 a_64174_n1608# VSS 1.05494f
C63 a_64034_n1608# VSS 1.35282f
C64 a_63770_n5048# VSS 2.75858f
C65 a_63629_n5048# VSS 2.14835f
C66 a_63489_n5048# VSS 2.14027f
C67 a_63349_n5048# VSS 2.16206f
C68 a_63206_n5048# VSS 2.13119f
C69 a_63070_n5048# VSS 3.29616f
C70 a_63070_1752.t0 VSS 0.05073f $ **FLOATING
C71 a_63070_1752.t1 VSS 0.05073f $ **FLOATING
C72 a_63070_n5420.t0 VSS 0.2135f $ **FLOATING
C73 a_63070_n5420.t1 VSS 0.2135f $ **FLOATING
C74 a_63206_n5420.t0 VSS 0.33033f $ **FLOATING
C75 a_63206_n5420.t1 VSS 0.33033f $ **FLOATING
C76 a_63349_1752.t0 VSS 0.08496f $ **FLOATING
C77 a_63349_1752.t1 VSS 0.08496f $ **FLOATING
C78 a_63349_n5420.t0 VSS 0.30702f $ **FLOATING
C79 a_63349_n5420.t1 VSS 0.30702f $ **FLOATING
C80 a_63489_n5420.t0 VSS 0.31611f $ **FLOATING
C81 a_63489_n5420.t1 VSS 0.31611f $ **FLOATING
C82 a_63629_1752.t0 VSS 0.06262f $ **FLOATING
C83 a_63629_1752.t1 VSS 0.06262f $ **FLOATING
C84 a_63629_n5420.t0 VSS 0.21095f $ **FLOATING
C85 a_63629_n5420.t1 VSS 0.21095f $ **FLOATING
C86 a_64034_n1694.t0 VSS 0.10694f $ **FLOATING
C87 a_64034_n1694.t1 VSS 0.10694f $ **FLOATING
C88 a_64174_1752.t0 VSS 0.06086f $ **FLOATING
C89 a_64174_1752.t1 VSS 0.06086f $ **FLOATING
C90 a_64841_n448.t1 VSS 0.1769f $ **FLOATING
C91 a_64841_n448.n0 VSS 0.43612f $ **FLOATING
C92 a_64841_n448.n1 VSS 0.43584f $ **FLOATING
C93 a_64841_n448.t3 VSS 0.19495f $ **FLOATING
C94 a_64841_n448.t2 VSS 0.63263f $ **FLOATING
C95 a_64841_n448.n2 VSS 0.06951f $ **FLOATING
C96 a_64841_n448.t7 VSS 0.63263f $ **FLOATING
C97 a_64841_n448.n3 VSS 0.06277f $ **FLOATING
C98 a_64841_n448.t6 VSS 0.63263f $ **FLOATING
C99 a_64841_n448.n4 VSS 0.06277f $ **FLOATING
C100 a_64841_n448.t4 VSS 0.63263f $ **FLOATING
C101 a_64841_n448.n5 VSS 0.13742f $ **FLOATING
C102 a_64841_n448.t5 VSS 0.22144f $ **FLOATING
C103 a_64841_n448.t0 VSS 0.09694f $ **FLOATING
C104 a_64851_n1595.t1 VSS 0.10351f $ **FLOATING
C105 a_64851_n1595.n0 VSS 1.37597f $ **FLOATING
C106 a_64851_n1595.t0 VSS 0.40435f $ **FLOATING
C107 a_64851_n1595.t3 VSS 0.76359f $ **FLOATING
C108 a_64851_n1595.t2 VSS 0.40386f $ **FLOATING
C109 a_64851_n1595.n1 VSS 0.36162f $ **FLOATING
C110 a_63770_n5134.t0 VSS 0.06507f $ **FLOATING
C111 a_63770_n5134.n0 VSS 0.17405f $ **FLOATING
C112 a_63770_n5134.t1 VSS 0.06645f $ **FLOATING
C113 a_63770_n5134.t2 VSS 0.27022f $ **FLOATING
C114 a_63770_n5134.n1 VSS 2.17382f $ **FLOATING
C115 a_63770_n5134.t4 VSS 0.37998f $ **FLOATING
C116 a_63770_n5134.t3 VSS 0.35718f $ **FLOATING
C117 a_63770_n5134.n2 VSS 0.90081f $ **FLOATING
C118 a_65812_n248.t2 VSS 0.44545f $ **FLOATING
C119 a_65812_n248.n0 VSS 0.99573f $ **FLOATING
C120 a_65812_n248.t0 VSS 0.15595f $ **FLOATING
C121 a_65812_n248.t1 VSS 0.21257f $ **FLOATING
C122 a_66395_n630.t0 VSS 0.02346f $ **FLOATING
C123 a_66395_n630.t1 VSS 0.02346f $ **FLOATING
C124 a_66531_1256.t3 VSS 0.01869f $ **FLOATING
C125 a_66531_1256.t0 VSS 0.11093f $ **FLOATING
C126 a_66531_1256.n0 VSS 0.02367f $ **FLOATING
C127 a_66531_1256.t6 VSS 0.11093f $ **FLOATING
C128 a_66531_1256.n1 VSS 0.02302f $ **FLOATING
C129 a_66531_1256.t5 VSS 0.11093f $ **FLOATING
C130 a_66531_1256.n2 VSS 0.02302f $ **FLOATING
C131 a_66531_1256.t2 VSS 0.11093f $ **FLOATING
C132 a_66531_1256.n3 VSS 0.04041f $ **FLOATING
C133 a_66531_1256.t1 VSS 0.01772f $ **FLOATING
C134 a_66531_1256.n4 VSS 0.14375f $ **FLOATING
C135 a_66531_1256.t4 VSS 0.09194f $ **FLOATING
C136 a_64887_n1663.t0 VSS 0.15078f $ **FLOATING
C137 a_64887_n1663.n0 VSS 0.89909f $ **FLOATING
C138 a_64887_n1663.t1 VSS 0.57597f $ **FLOATING
C139 a_64887_n1663.t2 VSS 0.20311f $ **FLOATING
C140 a_64034_n1920.t0 VSS 0.09915f $ **FLOATING
C141 a_64034_n1920.t1 VSS 0.09915f $ **FLOATING
C142 a_64034_n5392.t0 VSS 0.12273f $ **FLOATING
C143 a_63070_n12306.t0 VSS 0.017f $ **FLOATING
C144 a_63070_n12306.n0 VSS 0.02563f $ **FLOATING
C145 a_63070_n12306.n1 VSS 0.0142f $ **FLOATING
C146 a_63070_n12306.t2 VSS 8.70401f $ **FLOATING
C147 a_63206_n12306.t0 VSS 0.09538f $ **FLOATING
C148 a_63206_n12306.t1 VSS 0.09538f $ **FLOATING
C149 a_63489_n12306.t0 VSS 0.05675f $ **FLOATING
C150 a_63489_n12306.t1 VSS 0.05676f $ **FLOATING
C151 a_64174_n5392.t0 VSS 0.19056f $ **FLOATING
C152 a_64174_n8960.t0 VSS 0.10572f $ **FLOATING
C153 a_64174_n8960.t1 VSS 0.10572f $ **FLOATING
C154 a_65785_n2363.t0 VSS 0.10663f $ **FLOATING
C155 a_65785_n2363.t2 VSS 1.38008f $ **FLOATING
C156 a_65785_n2363.t1 VSS 0.12023f $ **FLOATING
C157 a_65785_n2363.n0 VSS 1.04777f $ **FLOATING
C158 a_64868_n3050.t0 VSS 0.15285f $ **FLOATING
C159 a_64868_n3050.n0 VSS 0.71103f $ **FLOATING
C160 a_64868_n3050.t2 VSS 1.24383f $ **FLOATING
C161 a_64868_n3050.t1 VSS 0.1251f $ **FLOATING
C162 a_64314_n5392.t0 VSS 0.11656f $ **FLOATING
C163 a_64314_n8960.t0 VSS 0.10629f $ **FLOATING
C164 a_64314_n8960.t1 VSS 0.10629f $ **FLOATING
C165 a_64174_n12406.t0 VSS 0.02153f $ **FLOATING
C166 a_64174_n12406.t1 VSS 0.02153f $ **FLOATING
C167 VLDO.t1 VSS 0.04703f $ **FLOATING
C168 VLDO.t20 VSS 0.08816f $ **FLOATING
C169 VLDO.n0 VSS 0.25268f $ **FLOATING
C170 VLDO.t5 VSS 0.18788f $ **FLOATING
C171 VLDO.n1 VSS 0.16545f $ **FLOATING
C172 VLDO.t3 VSS 0.04895f $ **FLOATING
C173 VLDO.t4 VSS 0.04914f $ **FLOATING
C174 VLDO.n2 VSS 0.05853f $ **FLOATING
C175 VLDO.t21 VSS 0.03622f $ **FLOATING
C176 VLDO.n3 VSS 0.35827f $ **FLOATING
C177 VLDO.n4 VSS 0.11656f $ **FLOATING
C178 VLDO.n5 VSS 0.01993f $ **FLOATING
C179 VLDO.n6 VSS 0.01054f $ **FLOATING
C180 VLDO.n8 VSS 0.04459f $ **FLOATING
C181 VLDO.n17 VSS 0.01115f $ **FLOATING
C182 VLDO.n24 VSS 0.09476f $ **FLOATING
C183 VLDO.t8 VSS 0.11947f $ **FLOATING
C184 VLDO.t10 VSS 0.04243f $ **FLOATING
C185 VLDO.n30 VSS 0.0236f $ **FLOATING
C186 VLDO.n31 VSS 0.06165f $ **FLOATING
C187 VLDO.n34 VSS 0.01055f $ **FLOATING
C188 VLDO.t9 VSS 0.03716f $ **FLOATING
C189 VLDO.n37 VSS 0.01752f $ **FLOATING
C190 VLDO.n38 VSS 0.02217f $ **FLOATING
C191 VLDO.t11 VSS 0.11947f $ **FLOATING
C192 VLDO.t12 VSS 0.04243f $ **FLOATING
C193 VLDO.n39 VSS 0.0236f $ **FLOATING
C194 VLDO.n40 VSS 0.06168f $ **FLOATING
C195 VLDO.n43 VSS 0.01034f $ **FLOATING
C196 VLDO.n44 VSS 0.01197f $ **FLOATING
C197 VLDO.n49 VSS 0.01115f $ **FLOATING
C198 VLDO.n51 VSS 0.01181f $ **FLOATING
C199 VLDO.n52 VSS 0.28198f $ **FLOATING
C200 VLDO.n54 VSS 0.35739f $ **FLOATING
C201 VLDO.t18 VSS 0.0197f $ **FLOATING
C202 VLDO.t17 VSS 0.03109f $ **FLOATING
C203 VLDO.n55 VSS 0.01677f $ **FLOATING
C204 VLDO.n56 VSS 0.01109f $ **FLOATING
C205 VLDO.n57 VSS 0.011f $ **FLOATING
C206 VLDO.n58 VSS 0.01068f $ **FLOATING
C207 VLDO.n59 VSS 0.011f $ **FLOATING
C208 VLDO.t16 VSS 0.01969f $ **FLOATING
C209 VLDO.t14 VSS 0.03109f $ **FLOATING
C210 VLDO.n60 VSS 0.01674f $ **FLOATING
C211 VLDO.n63 VSS 0.01068f $ **FLOATING
C212 VLDO.t15 VSS 0.01858f $ **FLOATING
C213 VLDO.n64 VSS 0.05852f $ **FLOATING
C214 VLDO.n65 VSS 0.06181f $ **FLOATING
C215 VLDO.t0 VSS 4.13916f $ **FLOATING
C216 VLDO.n66 VSS 0.24272f $ **FLOATING
C217 VLDO.n68 VSS 0.01872f $ **FLOATING
C218 VLDO.n69 VSS 0.01109f $ **FLOATING
C219 VLDO.n70 VSS 0.01078f $ **FLOATING
C220 VLDO.t19 VSS 0.01858f $ **FLOATING
C221 VLDO.n71 VSS 0.01078f $ **FLOATING
C222 VLDO.n73 VSS 0.04692f $ **FLOATING
C223 VLDO.n74 VSS 0.05777f $ **FLOATING
C224 VLDO.n75 VSS 0.05176f $ **FLOATING
C225 VLDO.n76 VSS 0.08013f $ **FLOATING
C226 VLDO.n77 VSS 0.12172f $ **FLOATING
C227 VLDO.n78 VSS 0.0798f $ **FLOATING
C228 VLDO.n79 VSS 0.01115f $ **FLOATING
C229 VLDO.n80 VSS 0.01115f $ **FLOATING
C230 VLDO.n81 VSS 0.01115f $ **FLOATING
C231 VLDO.n82 VSS 0.01115f $ **FLOATING
C232 VLDO.n83 VSS 0.01115f $ **FLOATING
C233 VLDO.n84 VSS 0.01115f $ **FLOATING
C234 VLDO.n85 VSS 0.01115f $ **FLOATING
C235 VLDO.n86 VSS 0.01328f $ **FLOATING
C236 VLDO.n87 VSS 0.01328f $ **FLOATING
C237 VLDO.n88 VSS 0.01328f $ **FLOATING
C238 VLDO.n89 VSS 0.01328f $ **FLOATING
C239 VLDO.n90 VSS 0.01115f $ **FLOATING
C240 VLDO.n91 VSS 0.01115f $ **FLOATING
C241 VLDO.n92 VSS 0.01115f $ **FLOATING
C242 VLDO.n93 VSS 0.01115f $ **FLOATING
C243 VLDO.n94 VSS 0.01115f $ **FLOATING
C244 VLDO.n95 VSS 0.01027f $ **FLOATING
C245 VLDO.n97 VSS 0.01441f $ **FLOATING
C246 VLDO.n98 VSS 0.01115f $ **FLOATING
C247 VLDO.n100 VSS 0.01355f $ **FLOATING
C248 VLDO.t13 VSS 0.03716f $ **FLOATING
C249 VLDO.n103 VSS 0.26149f $ **FLOATING
C250 VLDO.t2 VSS 3.11516f $ **FLOATING
C251 VLDO.n106 VSS 0.01115f $ **FLOATING
C252 VLDO.n107 VSS 0.0209f $ **FLOATING
C253 VLDO.n108 VSS 0.05428f $ **FLOATING
C254 VLDO.n109 VSS 0.07179f $ **FLOATING
C255 VLDO.t22 VSS 0.0635f $ **FLOATING
C256 VLDO.n110 VSS 0.18223f $ **FLOATING
C257 VBGR.t0 VSS 0.51761f $ **FLOATING
C258 VBGR.t1 VSS 0.51296f $ **FLOATING
C259 VBGR.n0 VSS 0.37017f $ **FLOATING
C260 RESET.t3 VSS 7.87985f $ **FLOATING
C261 RESET.n1 VSS 0.01599f $ **FLOATING
C262 RESET.n4 VSS 0.02756f $ **FLOATING
.ends
