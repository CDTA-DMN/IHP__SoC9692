* NGSPICE file created from clock_final_2.ext - technology: ihp-sg13g2

.subckt clock_final_2 VDD VSS Vcon Vout
X0 Vout.t0 a_9620_3460.t3 VDD.t1 VDD.t0 sg13_lv_pmos ad=1.088p pd=7.08u as=1.088p ps=7.08u w=3.2u l=0.13u
X1 a_9620_3460.t0 a_1519_1531.t4 VDD.t2 VDD.t0 sg13_lv_pmos ad=1.088p pd=7.08u as=1.088p ps=7.08u w=3.2u l=0.13u
X2 VDD.t10 a_379_2010.t1 a_379_2010.t2 VDD.t6 sg13_lv_pmos ad=1.02p pd=6.68u as=1.02p ps=6.68u w=3u l=9u
X3 a_6064_725.t0 a_4264_1495.t2 a_1587_1495.t1 VSS.t1 sg13_lv_nmos ad=0.51p pd=3.68u as=0.51p ps=3.68u w=1.5u l=9u
X4 a_9620_3460.t1 a_1519_1531.t3 VSS.t5 VSS.t4 sg13_lv_nmos ad=0.51p pd=3.68u as=0.51p ps=3.68u w=1.5u l=0.13u
X5 a_8732_725.t0 Vcon.t0 VSS.t10 VSS.t9 sg13_lv_nmos ad=0.51p pd=3.68u as=0.51p ps=3.68u w=1.5u l=9u
X6 a_6064_3981.t1 a_379_2010.t4 VDD.t9 VDD.t5 sg13_lv_pmos ad=1.02p pd=6.68u as=1.02p ps=6.68u w=3u l=9u
X7 a_3387_2714.t1 a_1587_1495.t3 a_1519_1531.t0 VDD.t4 sg13_lv_pmos ad=1.02p pd=6.68u as=1.02p ps=6.68u w=3u l=9u
X8 a_8732_2713.t1 a_1519_1531.t5 a_4264_1495.t0 VDD.t3 sg13_lv_pmos ad=1.02p pd=6.68u as=1.02p ps=6.68u w=3u l=9u
X9 a_3387_725.t0 a_1587_1495.t2 a_1519_1531.t1 VSS.t0 sg13_lv_nmos ad=0.51p pd=3.68u as=0.51p ps=3.68u w=1.5u l=9u
X10 a_3387_725.t1 Vcon.t2 VSS.t6 VSS.t0 sg13_lv_nmos ad=0.51p pd=3.68u as=0.51p ps=3.68u w=1.5u l=9u
X11 a_8732_2713.t0 a_379_2010.t3 VDD.t8 VDD.t3 sg13_lv_pmos ad=1.02p pd=6.68u as=1.02p ps=6.68u w=3u l=9u
X12 a_6064_725.t1 Vcon.t1 VSS.t11 VSS.t1 sg13_lv_nmos ad=0.51p pd=3.68u as=0.51p ps=3.68u w=1.5u l=9u
X13 a_3387_2714.t0 a_379_2010.t5 VDD.t7 VDD.t6 sg13_lv_pmos ad=1.02p pd=6.68u as=1.02p ps=6.68u w=3u l=9u
X14 a_6064_3981.t0 a_4264_1495.t3 a_1587_1495.t0 VDD.t5 sg13_lv_pmos ad=1.02p pd=6.68u as=1.02p ps=6.68u w=3u l=9u
X15 a_379_2010.t0 Vcon.t3 VSS.t8 VSS.t7 sg13_lv_nmos ad=0.51p pd=3.68u as=0.51p ps=3.68u w=1.5u l=9u
X16 a_8732_725.t1 a_1519_1531.t2 a_4264_1495.t1 VSS.t9 sg13_lv_nmos ad=0.51p pd=3.68u as=0.51p ps=3.68u w=1.5u l=9u
X17 Vout.t1 a_9620_3460.t2 VSS.t3 VSS.t2 sg13_lv_nmos ad=0.51p pd=3.68u as=0.51p ps=3.68u w=1.5u l=0.13u
C0 VDD Vout 0.62781f
C1 VDD m2_9092_2412# 0.3013f
R0 Vcon.n0 Vcon.t0 30.3673
R1 Vcon.n0 Vcon.t1 24.4977
R2 Vcon.n1 Vcon.t2 24.4977
R3 Vcon.n2 Vcon.n1 24.4401
R4 Vcon.n2 Vcon.t3 24.0005
R5 Vcon.n1 Vcon.n0 5.8921
R6 Vcon Vcon.n2 0.6429
R7 Vout.n0 Vout.t1 14.6566
R8 Vout.n0 Vout.t0 12.8979
R9 Vout Vout.n0 0.5549
R10 VDD.n281 VDD.n148 17.0005
R11 VDD.n278 VDD.n277 17.0005
R12 VDD.n278 VDD.n275 17.0005
R13 VDD.n278 VDD.n273 17.0005
R14 VDD.n486 VDD.n8 17.0005
R15 VDD.n486 VDD.n9 17.0005
R16 VDD.n486 VDD.n11 17.0005
R17 VDD.n486 VDD.n12 17.0005
R18 VDD.n486 VDD.n14 17.0005
R19 VDD.n486 VDD.n15 17.0005
R20 VDD.n486 VDD.n17 17.0005
R21 VDD.n486 VDD.n18 17.0005
R22 VDD.n486 VDD.n20 17.0005
R23 VDD.n486 VDD.n21 17.0005
R24 VDD.n486 VDD.n23 17.0005
R25 VDD.n486 VDD.n24 17.0005
R26 VDD.n486 VDD.n26 17.0005
R27 VDD.n486 VDD.n27 17.0005
R28 VDD.n486 VDD.n29 17.0005
R29 VDD.n486 VDD.n30 17.0005
R30 VDD.n486 VDD.n32 17.0005
R31 VDD.n486 VDD.n33 17.0005
R32 VDD.n486 VDD.n35 17.0005
R33 VDD.n486 VDD.n36 17.0005
R34 VDD.n486 VDD.n38 17.0005
R35 VDD.n486 VDD.n39 17.0005
R36 VDD.n486 VDD.n41 17.0005
R37 VDD.n486 VDD.n42 17.0005
R38 VDD.n486 VDD.n44 17.0005
R39 VDD.n486 VDD.n45 17.0005
R40 VDD.n486 VDD.n47 17.0005
R41 VDD.n486 VDD.n48 17.0005
R42 VDD.n486 VDD.n50 17.0005
R43 VDD.n486 VDD.n51 17.0005
R44 VDD.n486 VDD.n53 17.0005
R45 VDD.n486 VDD.n54 17.0005
R46 VDD.n486 VDD.n56 17.0005
R47 VDD.n486 VDD.n57 17.0005
R48 VDD.n486 VDD.n59 17.0005
R49 VDD.n486 VDD.n485 17.0005
R50 VDD.n461 VDD.n89 17.0005
R51 VDD.n461 VDD.n460 17.0005
R52 VDD.n457 VDD.n395 17.0005
R53 VDD.n457 VDD.n456 17.0005
R54 VDD.n454 VDD.n396 17.0005
R55 VDD.n454 VDD.n453 17.0005
R56 VDD.n451 VDD.n397 17.0005
R57 VDD.n451 VDD.n450 17.0005
R58 VDD.n448 VDD.n398 17.0005
R59 VDD.n448 VDD.n447 17.0005
R60 VDD.n445 VDD.n399 17.0005
R61 VDD.n445 VDD.n444 17.0005
R62 VDD.n442 VDD.n400 17.0005
R63 VDD.n442 VDD.n441 17.0005
R64 VDD.n439 VDD.n401 17.0005
R65 VDD.n439 VDD.n438 17.0005
R66 VDD.n436 VDD.n402 17.0005
R67 VDD.n436 VDD.n435 17.0005
R68 VDD.n433 VDD.n403 17.0005
R69 VDD.n433 VDD.n432 17.0005
R70 VDD.n430 VDD.n404 17.0005
R71 VDD.n430 VDD.n429 17.0005
R72 VDD.n427 VDD.n405 17.0005
R73 VDD.n427 VDD.n426 17.0005
R74 VDD.n424 VDD.n406 17.0005
R75 VDD.n424 VDD.n423 17.0005
R76 VDD.n421 VDD.n407 17.0005
R77 VDD.n421 VDD.n420 17.0005
R78 VDD.n418 VDD.n408 17.0005
R79 VDD.n418 VDD.n417 17.0005
R80 VDD.n415 VDD.n409 17.0005
R81 VDD.n415 VDD.n414 17.0005
R82 VDD.n412 VDD.n410 17.0005
R83 VDD.n412 VDD.n411 17.0005
R84 VDD.n483 VDD.n64 17.0005
R85 VDD.n484 VDD.n483 17.0005
R86 VDD.n207 VDD.t6 8.501
R87 VDD.n210 VDD.t6 8.501
R88 VDD.n212 VDD.t6 8.501
R89 VDD.n214 VDD.t6 8.501
R90 VDD.n216 VDD.t6 8.501
R91 VDD.n218 VDD.t6 8.501
R92 VDD.n220 VDD.t6 8.501
R93 VDD.n222 VDD.t6 8.501
R94 VDD.n224 VDD.t6 8.501
R95 VDD.n226 VDD.t6 8.501
R96 VDD.n228 VDD.t6 8.501
R97 VDD.n230 VDD.t6 8.501
R98 VDD.n232 VDD.t6 8.501
R99 VDD.n234 VDD.t6 8.501
R100 VDD.n236 VDD.t6 8.501
R101 VDD.n238 VDD.t6 8.501
R102 VDD.t6 VDD.n204 8.501
R103 VDD.n458 VDD.n86 8.501
R104 VDD.n468 VDD.n5 8.501
R105 VDD.n470 VDD.n5 8.501
R106 VDD.n67 VDD.n5 8.501
R107 VDD.n475 VDD.n5 8.501
R108 VDD.n477 VDD.n5 8.501
R109 VDD.n459 VDD.n458 8.501
R110 VDD.n455 VDD.n85 8.501
R111 VDD.n452 VDD.n84 8.501
R112 VDD.n449 VDD.n83 8.501
R113 VDD.n446 VDD.n82 8.501
R114 VDD.n443 VDD.n81 8.501
R115 VDD.n440 VDD.n80 8.501
R116 VDD.n437 VDD.n79 8.501
R117 VDD.n434 VDD.t3 8.501
R118 VDD.n431 VDD.n78 8.501
R119 VDD.n428 VDD.n77 8.501
R120 VDD.n425 VDD.n76 8.501
R121 VDD.n422 VDD.n75 8.501
R122 VDD.n419 VDD.n74 8.501
R123 VDD.n416 VDD.n73 8.501
R124 VDD.n413 VDD.n72 8.501
R125 VDD.n71 VDD.n63 8.501
R126 VDD.n482 VDD.n5 8.501
R127 VDD.n394 VDD.n90 8.501
R128 VDD.n394 VDD.n91 8.501
R129 VDD.n394 VDD.n92 8.501
R130 VDD.n394 VDD.n93 8.501
R131 VDD.n394 VDD.n94 8.501
R132 VDD.n394 VDD.n95 8.501
R133 VDD.n394 VDD.n96 8.501
R134 VDD.t4 VDD.n390 8.501
R135 VDD.t4 VDD.n128 8.501
R136 VDD.t4 VDD.n127 8.501
R137 VDD.t4 VDD.n126 8.501
R138 VDD.t4 VDD.n125 8.501
R139 VDD.t4 VDD.n124 8.501
R140 VDD.t4 VDD.n123 8.501
R141 VDD.n388 VDD.n118 8.501
R142 VDD.n131 VDD.n115 8.501
R143 VDD.n322 VDD.n114 8.501
R144 VDD.n325 VDD.n113 8.501
R145 VDD.n328 VDD.n112 8.501
R146 VDD.n331 VDD.n111 8.501
R147 VDD.n334 VDD.n110 8.501
R148 VDD.n337 VDD.n109 8.501
R149 VDD.n340 VDD.n108 8.501
R150 VDD.n343 VDD.t5 8.501
R151 VDD.n346 VDD.n107 8.501
R152 VDD.n349 VDD.n106 8.501
R153 VDD.n352 VDD.n105 8.501
R154 VDD.n355 VDD.n104 8.501
R155 VDD.n358 VDD.n103 8.501
R156 VDD.n361 VDD.n102 8.501
R157 VDD.n364 VDD.n101 8.501
R158 VDD.n366 VDD.n100 8.501
R159 VDD.n464 VDD.n85 8.5005
R160 VDD.n464 VDD.n84 8.5005
R161 VDD.n464 VDD.n83 8.5005
R162 VDD.n464 VDD.n82 8.5005
R163 VDD.n464 VDD.n81 8.5005
R164 VDD.n464 VDD.n80 8.5005
R165 VDD.n464 VDD.n79 8.5005
R166 VDD.n464 VDD.t3 8.5005
R167 VDD.n464 VDD.n78 8.5005
R168 VDD.n464 VDD.n77 8.5005
R169 VDD.n464 VDD.n76 8.5005
R170 VDD.n464 VDD.n75 8.5005
R171 VDD.n464 VDD.n74 8.5005
R172 VDD.n464 VDD.n73 8.5005
R173 VDD.n464 VDD.n72 8.5005
R174 VDD.n464 VDD.n71 8.5005
R175 VDD.n392 VDD.n118 8.5005
R176 VDD.n392 VDD.n115 8.5005
R177 VDD.n392 VDD.n114 8.5005
R178 VDD.n392 VDD.n113 8.5005
R179 VDD.n392 VDD.n112 8.5005
R180 VDD.n392 VDD.n111 8.5005
R181 VDD.n392 VDD.n110 8.5005
R182 VDD.n392 VDD.n109 8.5005
R183 VDD.n392 VDD.n108 8.5005
R184 VDD.n392 VDD.t5 8.5005
R185 VDD.n392 VDD.n107 8.5005
R186 VDD.n392 VDD.n106 8.5005
R187 VDD.n392 VDD.n105 8.5005
R188 VDD.n392 VDD.n104 8.5005
R189 VDD.n392 VDD.n103 8.5005
R190 VDD.n392 VDD.n102 8.5005
R191 VDD.n392 VDD.n101 8.5005
R192 VDD.n392 VDD.n100 8.5005
R193 VDD.n150 VDD.n121 8.49122
R194 VDD.n152 VDD.n121 8.49122
R195 VDD.n154 VDD.n121 8.49122
R196 VDD.n156 VDD.n121 8.49122
R197 VDD.n158 VDD.n121 8.49122
R198 VDD.n160 VDD.n121 8.49122
R199 VDD.n162 VDD.n121 8.49122
R200 VDD.n164 VDD.n121 8.49122
R201 VDD.n166 VDD.n121 8.49122
R202 VDD.n168 VDD.n121 8.49122
R203 VDD.n170 VDD.n121 8.49122
R204 VDD.n172 VDD.n121 8.49122
R205 VDD.n174 VDD.n121 8.49122
R206 VDD.n176 VDD.n121 8.49122
R207 VDD.n178 VDD.n121 8.49122
R208 VDD.n180 VDD.n121 8.49122
R209 VDD.n183 VDD.n121 8.49122
R210 VDD.n182 VDD.n121 8.49122
R211 VDD.n281 VDD.n184 8.49122
R212 VDD.n281 VDD.n181 8.49122
R213 VDD.n281 VDD.n179 8.49122
R214 VDD.n281 VDD.n177 8.49122
R215 VDD.n281 VDD.n175 8.49122
R216 VDD.n281 VDD.n173 8.49122
R217 VDD.n281 VDD.n171 8.49122
R218 VDD.n281 VDD.n169 8.49122
R219 VDD.n281 VDD.n165 8.49122
R220 VDD.n281 VDD.n163 8.49122
R221 VDD.n281 VDD.n161 8.49122
R222 VDD.n281 VDD.n159 8.49122
R223 VDD.n281 VDD.n157 8.49122
R224 VDD.n281 VDD.n155 8.49122
R225 VDD.n281 VDD.n153 8.49122
R226 VDD.n281 VDD.n151 8.49122
R227 VDD.n281 VDD.n147 8.49122
R228 VDD.n384 VDD.n132 8.49122
R229 VDD.n385 VDD.n384 8.49122
R230 VDD.n384 VDD.n290 8.49122
R231 VDD.n384 VDD.n292 8.49122
R232 VDD.n384 VDD.n294 8.49122
R233 VDD.n384 VDD.n296 8.49122
R234 VDD.n384 VDD.n298 8.49122
R235 VDD.n384 VDD.n300 8.49122
R236 VDD.n384 VDD.n302 8.49122
R237 VDD.n384 VDD.n304 8.49122
R238 VDD.n384 VDD.n306 8.49122
R239 VDD.n384 VDD.n308 8.49122
R240 VDD.n384 VDD.n310 8.49122
R241 VDD.n384 VDD.n312 8.49122
R242 VDD.n384 VDD.n314 8.49122
R243 VDD.n384 VDD.n316 8.49122
R244 VDD.n384 VDD.n318 8.49122
R245 VDD.n384 VDD.n383 8.49122
R246 VDD.n389 VDD.n130 8.49122
R247 VDD.n387 VDD.n386 8.49122
R248 VDD.n321 VDD.n133 8.49122
R249 VDD.n324 VDD.n323 8.49122
R250 VDD.n327 VDD.n326 8.49122
R251 VDD.n330 VDD.n329 8.49122
R252 VDD.n333 VDD.n332 8.49122
R253 VDD.n336 VDD.n335 8.49122
R254 VDD.n339 VDD.n338 8.49122
R255 VDD.n345 VDD.n344 8.49122
R256 VDD.n348 VDD.n347 8.49122
R257 VDD.n351 VDD.n350 8.49122
R258 VDD.n354 VDD.n353 8.49122
R259 VDD.n357 VDD.n356 8.49122
R260 VDD.n360 VDD.n359 8.49122
R261 VDD.n363 VDD.n362 8.49122
R262 VDD.n365 VDD.n320 8.49122
R263 VDD.n382 VDD.n367 8.49122
R264 VDD.n281 VDD.n185 8.49117
R265 VDD.n281 VDD.n186 8.49117
R266 VDD.n281 VDD.n187 8.49117
R267 VDD.n281 VDD.n188 8.49117
R268 VDD.n281 VDD.n189 8.49117
R269 VDD.n281 VDD.n190 8.49117
R270 VDD.n281 VDD.n191 8.49117
R271 VDD.n281 VDD.n192 8.49117
R272 VDD.n281 VDD.n193 8.49117
R273 VDD.n281 VDD.n194 8.49117
R274 VDD.n281 VDD.n195 8.49117
R275 VDD.n281 VDD.n196 8.49117
R276 VDD.n281 VDD.n197 8.49117
R277 VDD.n281 VDD.n198 8.49117
R278 VDD.n281 VDD.n199 8.49117
R279 VDD.n281 VDD.n200 8.49117
R280 VDD.n281 VDD.n201 8.49117
R281 VDD.n281 VDD.n280 8.49117
R282 VDD.n278 VDD.n276 8.49117
R283 VDD.n278 VDD.n272 8.49117
R284 VDD.n278 VDD.n271 8.49117
R285 VDD.n278 VDD.n270 8.49117
R286 VDD.n278 VDD.n269 8.49117
R287 VDD.n278 VDD.n268 8.49117
R288 VDD.n278 VDD.n267 8.49117
R289 VDD.n278 VDD.n265 8.49117
R290 VDD.n278 VDD.n264 8.49117
R291 VDD.n278 VDD.n263 8.49117
R292 VDD.n278 VDD.n262 8.49117
R293 VDD.n278 VDD.n261 8.49117
R294 VDD.n278 VDD.n260 8.49117
R295 VDD.n278 VDD.n259 8.49117
R296 VDD.n278 VDD.n202 8.49117
R297 VDD.n279 VDD.n278 8.49117
R298 VDD.n281 VDD.n167 8.48777
R299 VDD.n342 VDD.n341 8.48777
R300 VDD.n278 VDD.n266 8.48771
R301 VDD.n255 VDD.n209 8.46995
R302 VDD.n254 VDD.n211 8.46995
R303 VDD.n253 VDD.n213 8.46995
R304 VDD.n252 VDD.n215 8.46995
R305 VDD.n251 VDD.n217 8.46995
R306 VDD.n250 VDD.n219 8.46995
R307 VDD.n249 VDD.n221 8.46995
R308 VDD.n247 VDD.n225 8.46995
R309 VDD.n246 VDD.n227 8.46995
R310 VDD.n245 VDD.n229 8.46995
R311 VDD.n244 VDD.n231 8.46995
R312 VDD.n243 VDD.n233 8.46995
R313 VDD.n242 VDD.n235 8.46995
R314 VDD.n241 VDD.n237 8.46995
R315 VDD.n240 VDD.n239 8.46995
R316 VDD.n464 VDD.n463 8.46995
R317 VDD.n467 VDD.n466 8.46995
R318 VDD.n469 VDD.n68 8.46995
R319 VDD.n472 VDD.n471 8.46995
R320 VDD.n476 VDD.n66 8.46995
R321 VDD.n479 VDD.n478 8.46995
R322 VDD.n368 VDD.n98 8.46995
R323 VDD.n370 VDD.n369 8.46995
R324 VDD.n372 VDD.n371 8.46995
R325 VDD.n376 VDD.n375 8.46995
R326 VDD.n378 VDD.n377 8.46995
R327 VDD.n380 VDD.n379 8.46995
R328 VDD.n145 VDD.n129 8.46995
R329 VDD.n144 VDD.n134 8.46995
R330 VDD.n143 VDD.n135 8.46995
R331 VDD.n141 VDD.n137 8.46995
R332 VDD.n140 VDD.n138 8.46995
R333 VDD.n139 VDD.n119 8.46995
R334 VDD.n248 VDD.n223 8.45904
R335 VDD.n474 VDD.n473 8.44635
R336 VDD.n374 VDD.n373 8.44635
R337 VDD.n142 VDD.n136 8.44635
R338 VDD.n65 VDD.n5 5.66778
R339 VDD.n394 VDD.n393 5.66767
R340 VDD.n391 VDD.t4 5.66767
R341 VDD.n481 VDD.n480 5.62487
R342 VDD VDD.n490 4.8921
R343 VDD.n384 VDD.n288 4.251
R344 VDD.n384 VDD.n289 4.251
R345 VDD.n384 VDD.n291 4.251
R346 VDD.n384 VDD.n293 4.251
R347 VDD.n384 VDD.n295 4.251
R348 VDD.n384 VDD.n297 4.251
R349 VDD.n384 VDD.n299 4.251
R350 VDD.n384 VDD.n301 4.251
R351 VDD.n384 VDD.n303 4.251
R352 VDD.n384 VDD.n305 4.251
R353 VDD.n384 VDD.n307 4.251
R354 VDD.n384 VDD.n309 4.251
R355 VDD.n384 VDD.n311 4.251
R356 VDD.n384 VDD.n313 4.251
R357 VDD.n384 VDD.n315 4.251
R358 VDD.n384 VDD.n317 4.251
R359 VDD.n384 VDD.n319 4.251
R360 VDD.n486 VDD.n10 4.251
R361 VDD.n486 VDD.n13 4.251
R362 VDD.n486 VDD.n16 4.251
R363 VDD.n486 VDD.n19 4.251
R364 VDD.n486 VDD.n22 4.251
R365 VDD.n486 VDD.n25 4.251
R366 VDD.n486 VDD.n28 4.251
R367 VDD.n486 VDD.n31 4.251
R368 VDD.n486 VDD.n34 4.251
R369 VDD.n486 VDD.n37 4.251
R370 VDD.n486 VDD.n40 4.251
R371 VDD.n486 VDD.n43 4.251
R372 VDD.n486 VDD.n46 4.251
R373 VDD.n486 VDD.n49 4.251
R374 VDD.n486 VDD.n52 4.251
R375 VDD.n486 VDD.n55 4.251
R376 VDD.n486 VDD.n58 4.251
R377 VDD.n69 VDD.n5 4.251
R378 VDD.n116 VDD.t9 3.60093
R379 VDD.n70 VDD.t8 3.60093
R380 VDD.n274 VDD.t7 3.49176
R381 VDD.n208 VDD.t10 3.41143
R382 VDD.n3 VDD.t2 3.33221
R383 VDD.n1 VDD.t1 3.33221
R384 VDD.n257 VDD.n206 3.3033
R385 VDD.n488 VDD.n2 3.28157
R386 VDD.n392 VDD.n117 2.7239
R387 VDD.n489 VDD.n488 2.71665
R388 VDD.n368 VDD.n99 1.39307
R389 VDD.n466 VDD.n465 1.3904
R390 VDD.n88 VDD.n6 1.38453
R391 VDD.n287 VDD.n286 1.38399
R392 VDD.n284 VDD.n283 1.38171
R393 VDD.n285 VDD.n284 1.37353
R394 VDD.n381 VDD.n287 1.37148
R395 VDD.n61 VDD.n6 1.36761
R396 VDD.n490 VDD.n0 1.34948
R397 VDD.n465 VDD.n70 1.32003
R398 VDD.n116 VDD.n99 1.31097
R399 VDD.n60 VDD.n0 1.26234
R400 VDD.n463 VDD.n462 1.09276
R401 VDD.n240 VDD.n205 1.05409
R402 VDD.n488 VDD.n4 0.974415
R403 VDD.n257 VDD.n256 0.968216
R404 VDD.n285 VDD.n146 0.914142
R405 VDD.n462 VDD.n87 0.903574
R406 VDD.n384 VDD.n122 0.895737
R407 VDD.n384 VDD.n97 0.895737
R408 VDD.n486 VDD.n7 0.895737
R409 VDD.n487 VDD.n486 0.895737
R410 VDD.n461 VDD.n394 0.895237
R411 VDD.n256 VDD.n255 0.892863
R412 VDD.n205 VDD.n149 0.869243
R413 VDD.n256 VDD.n208 0.860771
R414 VDD.n283 VDD.n282 0.833133
R415 VDD.n282 VDD.n149 0.825684
R416 VDD.n203 VDD.n146 0.788085
R417 VDD.n60 VDD.n4 0.780249
R418 VDD.n281 VDD.n146 0.779936
R419 VDD.n4 VDD.n3 0.760719
R420 VDD.n282 VDD.n281 0.709867
R421 VDD.n278 VDD.n205 0.646839
R422 VDD.n462 VDD.n461 0.590135
R423 VDD.n139 VDD.n117 0.449724
R424 VDD.n2 VDD.n1 0.40082
R425 VDD.n117 VDD.n116 0.376813
R426 VDD.n490 VDD.n489 0.357963
R427 VDD.n3 VDD.n2 0.347606
R428 VDD.n489 VDD.n1 0.332655
R429 VDD.n206 VDD.n203 0.31697
R430 VDD.n374 VDD.n372 0.297565
R431 VDD.n376 VDD.n374 0.297565
R432 VDD.n142 VDD.n141 0.297565
R433 VDD.n143 VDD.n142 0.297565
R434 VDD.n473 VDD.n472 0.297565
R435 VDD.n473 VDD.n66 0.297565
R436 VDD.n208 VDD.n206 0.29498
R437 VDD.n480 VDD.n479 0.294636
R438 VDD.n249 VDD.n248 0.272189
R439 VDD.n248 VDD.n247 0.272189
R440 VDD.n488 VDD.t0 0.266125
R441 VDD.n370 VDD.n368 0.250378
R442 VDD.n372 VDD.n370 0.250378
R443 VDD.n378 VDD.n376 0.250378
R444 VDD.n380 VDD.n378 0.250378
R445 VDD.n140 VDD.n139 0.250378
R446 VDD.n141 VDD.n140 0.250378
R447 VDD.n144 VDD.n143 0.250378
R448 VDD.n145 VDD.n144 0.250378
R449 VDD.n466 VDD.n68 0.250378
R450 VDD.n472 VDD.n68 0.250378
R451 VDD.n479 VDD.n66 0.250378
R452 VDD.n255 VDD.n254 0.250378
R453 VDD.n254 VDD.n253 0.250378
R454 VDD.n253 VDD.n252 0.250378
R455 VDD.n252 VDD.n251 0.250378
R456 VDD.n251 VDD.n250 0.250378
R457 VDD.n250 VDD.n249 0.250378
R458 VDD.n247 VDD.n246 0.250378
R459 VDD.n246 VDD.n245 0.250378
R460 VDD.n245 VDD.n244 0.250378
R461 VDD.n244 VDD.n243 0.250378
R462 VDD.n243 VDD.n242 0.250378
R463 VDD.n242 VDD.n241 0.250378
R464 VDD.n241 VDD.n240 0.250378
R465 VDD.n258 VDD.t6 0.23759
R466 VDD.n465 VDD.n464 0.162269
R467 VDD.t4 VDD.n121 0.161627
R468 VDD.n281 VDD.n120 0.161377
R469 VDD.n392 VDD.n99 0.159686
R470 VDD.n463 VDD.n70 0.141939
R471 VDD.n381 VDD.n380 0.132772
R472 VDD.n286 VDD.n145 0.132772
R473 VDD.n488 VDD.n0 0.102833
R474 VDD.n480 VDD.n62 0.0888312
R475 VDD.n381 VDD.n87 0.0753691
R476 VDD.n286 VDD.n285 0.0753691
R477 VDD.n403 VDD.n33 0.0529084
R478 VDD.n266 VDD.n194 0.0477514
R479 VDD.n266 VDD.n193 0.0477514
R480 VDD.n341 VDD.n304 0.0475096
R481 VDD.n167 VDD.n166 0.0475096
R482 VDD.n168 VDD.n167 0.0475096
R483 VDD.n341 VDD.n302 0.0475096
R484 VDD.n280 VDD.n279 0.0408229
R485 VDD.n280 VDD.n202 0.0408229
R486 VDD.n259 VDD.n201 0.0408229
R487 VDD.n260 VDD.n200 0.0408229
R488 VDD.n261 VDD.n199 0.0408229
R489 VDD.n262 VDD.n198 0.0408229
R490 VDD.n263 VDD.n197 0.0408229
R491 VDD.n264 VDD.n196 0.0408229
R492 VDD.n265 VDD.n195 0.0408229
R493 VDD.n267 VDD.n193 0.0408229
R494 VDD.n268 VDD.n192 0.0408229
R495 VDD.n269 VDD.n191 0.0408229
R496 VDD.n270 VDD.n190 0.0408229
R497 VDD.n271 VDD.n189 0.0408229
R498 VDD.n272 VDD.n188 0.0408229
R499 VDD.n276 VDD.n186 0.0408229
R500 VDD.n276 VDD.n185 0.0408229
R501 VDD.n272 VDD.n187 0.0408229
R502 VDD.n271 VDD.n188 0.0408229
R503 VDD.n270 VDD.n189 0.0408229
R504 VDD.n269 VDD.n190 0.0408229
R505 VDD.n268 VDD.n191 0.0408229
R506 VDD.n267 VDD.n192 0.0408229
R507 VDD.n265 VDD.n194 0.0408229
R508 VDD.n264 VDD.n195 0.0408229
R509 VDD.n263 VDD.n196 0.0408229
R510 VDD.n262 VDD.n197 0.0408229
R511 VDD.n261 VDD.n198 0.0408229
R512 VDD.n260 VDD.n199 0.0408229
R513 VDD.n259 VDD.n200 0.0408229
R514 VDD.n202 VDD.n201 0.0408229
R515 VDD.n383 VDD.n320 0.0406172
R516 VDD.n362 VDD.n318 0.0406172
R517 VDD.n359 VDD.n316 0.0406172
R518 VDD.n356 VDD.n314 0.0406172
R519 VDD.n353 VDD.n312 0.0406172
R520 VDD.n350 VDD.n310 0.0406172
R521 VDD.n347 VDD.n308 0.0406172
R522 VDD.n344 VDD.n306 0.0406172
R523 VDD.n338 VDD.n302 0.0406172
R524 VDD.n335 VDD.n300 0.0406172
R525 VDD.n332 VDD.n298 0.0406172
R526 VDD.n329 VDD.n296 0.0406172
R527 VDD.n326 VDD.n294 0.0406172
R528 VDD.n323 VDD.n292 0.0406172
R529 VDD.n290 VDD.n133 0.0406172
R530 VDD.n386 VDD.n385 0.0406172
R531 VDD.n132 VDD.n130 0.0406172
R532 VDD.n150 VDD.n147 0.0406172
R533 VDD.n151 VDD.n150 0.0406172
R534 VDD.n153 VDD.n152 0.0406172
R535 VDD.n155 VDD.n154 0.0406172
R536 VDD.n157 VDD.n156 0.0406172
R537 VDD.n159 VDD.n158 0.0406172
R538 VDD.n161 VDD.n160 0.0406172
R539 VDD.n163 VDD.n162 0.0406172
R540 VDD.n165 VDD.n164 0.0406172
R541 VDD.n169 VDD.n168 0.0406172
R542 VDD.n171 VDD.n170 0.0406172
R543 VDD.n173 VDD.n172 0.0406172
R544 VDD.n175 VDD.n174 0.0406172
R545 VDD.n177 VDD.n176 0.0406172
R546 VDD.n179 VDD.n178 0.0406172
R547 VDD.n181 VDD.n180 0.0406172
R548 VDD.n184 VDD.n183 0.0406172
R549 VDD.n152 VDD.n151 0.0406172
R550 VDD.n154 VDD.n153 0.0406172
R551 VDD.n156 VDD.n155 0.0406172
R552 VDD.n158 VDD.n157 0.0406172
R553 VDD.n160 VDD.n159 0.0406172
R554 VDD.n162 VDD.n161 0.0406172
R555 VDD.n164 VDD.n163 0.0406172
R556 VDD.n166 VDD.n165 0.0406172
R557 VDD.n170 VDD.n169 0.0406172
R558 VDD.n172 VDD.n171 0.0406172
R559 VDD.n174 VDD.n173 0.0406172
R560 VDD.n176 VDD.n175 0.0406172
R561 VDD.n178 VDD.n177 0.0406172
R562 VDD.n180 VDD.n179 0.0406172
R563 VDD.n183 VDD.n181 0.0406172
R564 VDD.n184 VDD.n182 0.0406172
R565 VDD.n386 VDD.n132 0.0406172
R566 VDD.n385 VDD.n133 0.0406172
R567 VDD.n323 VDD.n290 0.0406172
R568 VDD.n326 VDD.n292 0.0406172
R569 VDD.n329 VDD.n294 0.0406172
R570 VDD.n332 VDD.n296 0.0406172
R571 VDD.n335 VDD.n298 0.0406172
R572 VDD.n338 VDD.n300 0.0406172
R573 VDD.n344 VDD.n304 0.0406172
R574 VDD.n347 VDD.n306 0.0406172
R575 VDD.n350 VDD.n308 0.0406172
R576 VDD.n353 VDD.n310 0.0406172
R577 VDD.n356 VDD.n312 0.0406172
R578 VDD.n359 VDD.n314 0.0406172
R579 VDD.n362 VDD.n316 0.0406172
R580 VDD.n320 VDD.n318 0.0406172
R581 VDD.n383 VDD.n382 0.0406172
R582 VDD.n277 VDD.n149 0.0398684
R583 VDD.n283 VDD.n148 0.0396623
R584 VDD.n485 VDD.n62 0.0390864
R585 VDD.n484 VDD.n59 0.0390864
R586 VDD.n64 VDD.n57 0.0390864
R587 VDD.n411 VDD.n56 0.0390864
R588 VDD.n410 VDD.n54 0.0390864
R589 VDD.n414 VDD.n53 0.0390864
R590 VDD.n409 VDD.n51 0.0390864
R591 VDD.n417 VDD.n50 0.0390864
R592 VDD.n408 VDD.n48 0.0390864
R593 VDD.n420 VDD.n47 0.0390864
R594 VDD.n407 VDD.n45 0.0390864
R595 VDD.n423 VDD.n44 0.0390864
R596 VDD.n406 VDD.n42 0.0390864
R597 VDD.n426 VDD.n41 0.0390864
R598 VDD.n405 VDD.n39 0.0390864
R599 VDD.n429 VDD.n38 0.0390864
R600 VDD.n404 VDD.n36 0.0390864
R601 VDD.n432 VDD.n35 0.0390864
R602 VDD.n435 VDD.n32 0.0390864
R603 VDD.n402 VDD.n30 0.0390864
R604 VDD.n438 VDD.n29 0.0390864
R605 VDD.n401 VDD.n27 0.0390864
R606 VDD.n441 VDD.n26 0.0390864
R607 VDD.n400 VDD.n24 0.0390864
R608 VDD.n444 VDD.n23 0.0390864
R609 VDD.n399 VDD.n21 0.0390864
R610 VDD.n447 VDD.n20 0.0390864
R611 VDD.n398 VDD.n18 0.0390864
R612 VDD.n450 VDD.n17 0.0390864
R613 VDD.n397 VDD.n15 0.0390864
R614 VDD.n453 VDD.n14 0.0390864
R615 VDD.n396 VDD.n12 0.0390864
R616 VDD.n456 VDD.n11 0.0390864
R617 VDD.n395 VDD.n9 0.0390864
R618 VDD.n460 VDD.n8 0.0390864
R619 VDD.n89 VDD.n88 0.0390864
R620 VDD.n275 VDD.n274 0.0253947
R621 VDD.n273 VDD.n187 0.0206614
R622 VDD.n277 VDD.n185 0.0206614
R623 VDD.n275 VDD.n186 0.0206614
R624 VDD.n279 VDD.n203 0.0206614
R625 VDD.n382 VDD.n381 0.0205586
R626 VDD.n286 VDD.n130 0.0205586
R627 VDD.n182 VDD.n148 0.0205586
R628 VDD.n285 VDD.n147 0.0205586
R629 VDD.n61 VDD.n60 0.0177775
R630 VDD.n274 VDD.n273 0.0149737
R631 VDD.n486 VDD.n6 0.00876291
R632 VDD.n384 VDD.n287 0.00865237
R633 VDD.n284 VDD.n121 0.00861664
R634 VDD.n478 VDD.n65 0.00166667
R635 VDD.n278 VDD.n258 0.00150696
R636 VDD.n258 VDD.n257 0.00149303
R637 VDD.n481 VDD.n65 0.00133332
R638 VDD.n62 VDD.n61 0.00107592
R639 VDD.n485 VDD.n484 0.00107592
R640 VDD.n64 VDD.n59 0.00107592
R641 VDD.n411 VDD.n57 0.00107592
R642 VDD.n410 VDD.n56 0.00107592
R643 VDD.n414 VDD.n54 0.00107592
R644 VDD.n409 VDD.n53 0.00107592
R645 VDD.n417 VDD.n51 0.00107592
R646 VDD.n408 VDD.n50 0.00107592
R647 VDD.n420 VDD.n48 0.00107592
R648 VDD.n407 VDD.n47 0.00107592
R649 VDD.n423 VDD.n45 0.00107592
R650 VDD.n406 VDD.n44 0.00107592
R651 VDD.n426 VDD.n42 0.00107592
R652 VDD.n405 VDD.n41 0.00107592
R653 VDD.n429 VDD.n39 0.00107592
R654 VDD.n404 VDD.n38 0.00107592
R655 VDD.n432 VDD.n36 0.00107592
R656 VDD.n403 VDD.n35 0.00107592
R657 VDD.n435 VDD.n33 0.00107592
R658 VDD.n402 VDD.n32 0.00107592
R659 VDD.n438 VDD.n30 0.00107592
R660 VDD.n401 VDD.n29 0.00107592
R661 VDD.n441 VDD.n27 0.00107592
R662 VDD.n400 VDD.n26 0.00107592
R663 VDD.n444 VDD.n24 0.00107592
R664 VDD.n399 VDD.n23 0.00107592
R665 VDD.n447 VDD.n21 0.00107592
R666 VDD.n398 VDD.n20 0.00107592
R667 VDD.n450 VDD.n18 0.00107592
R668 VDD.n397 VDD.n17 0.00107592
R669 VDD.n453 VDD.n15 0.00107592
R670 VDD.n396 VDD.n14 0.00107592
R671 VDD.n456 VDD.n12 0.00107592
R672 VDD.n395 VDD.n11 0.00107592
R673 VDD.n460 VDD.n9 0.00107592
R674 VDD.n89 VDD.n8 0.00107592
R675 VDD.n88 VDD.n87 0.00107592
R676 VDD.n393 VDD.n98 0.001
R677 VDD.n98 VDD.n90 0.001
R678 VDD.n369 VDD.n91 0.001
R679 VDD.n371 VDD.n92 0.001
R680 VDD.n373 VDD.n93 0.001
R681 VDD.n375 VDD.n94 0.001
R682 VDD.n377 VDD.n95 0.001
R683 VDD.n379 VDD.n96 0.001
R684 VDD.n366 VDD.n365 0.001
R685 VDD.n364 VDD.n363 0.001
R686 VDD.n361 VDD.n360 0.001
R687 VDD.n358 VDD.n357 0.001
R688 VDD.n355 VDD.n354 0.001
R689 VDD.n352 VDD.n351 0.001
R690 VDD.n349 VDD.n348 0.001
R691 VDD.n346 VDD.n345 0.001
R692 VDD.n343 VDD.n342 0.001
R693 VDD.n340 VDD.n339 0.001
R694 VDD.n337 VDD.n336 0.001
R695 VDD.n334 VDD.n333 0.001
R696 VDD.n331 VDD.n330 0.001
R697 VDD.n328 VDD.n327 0.001
R698 VDD.n325 VDD.n324 0.001
R699 VDD.n322 VDD.n321 0.001
R700 VDD.n387 VDD.n131 0.001
R701 VDD.n389 VDD.n388 0.001
R702 VDD.n391 VDD.n119 0.001
R703 VDD.n123 VDD.n119 0.001
R704 VDD.n138 VDD.n124 0.001
R705 VDD.n137 VDD.n125 0.001
R706 VDD.n136 VDD.n126 0.001
R707 VDD.n135 VDD.n127 0.001
R708 VDD.n134 VDD.n128 0.001
R709 VDD.n390 VDD.n129 0.001
R710 VDD.n467 VDD.n69 0.001
R711 VDD.n468 VDD.n467 0.001
R712 VDD.n470 VDD.n469 0.001
R713 VDD.n471 VDD.n67 0.001
R714 VDD.n475 VDD.n474 0.001
R715 VDD.n477 VDD.n476 0.001
R716 VDD.n483 VDD.n482 0.001
R717 VDD.n412 VDD.n63 0.001
R718 VDD.n415 VDD.n413 0.001
R719 VDD.n418 VDD.n416 0.001
R720 VDD.n421 VDD.n419 0.001
R721 VDD.n424 VDD.n422 0.001
R722 VDD.n427 VDD.n425 0.001
R723 VDD.n430 VDD.n428 0.001
R724 VDD.n433 VDD.n431 0.001
R725 VDD.n436 VDD.n434 0.001
R726 VDD.n439 VDD.n437 0.001
R727 VDD.n442 VDD.n440 0.001
R728 VDD.n445 VDD.n443 0.001
R729 VDD.n448 VDD.n446 0.001
R730 VDD.n451 VDD.n449 0.001
R731 VDD.n454 VDD.n452 0.001
R732 VDD.n457 VDD.n455 0.001
R733 VDD.n461 VDD.n459 0.001
R734 VDD.n461 VDD.n86 0.001
R735 VDD.n257 VDD.n207 0.001
R736 VDD.n210 VDD.n209 0.001
R737 VDD.n212 VDD.n211 0.001
R738 VDD.n214 VDD.n213 0.001
R739 VDD.n216 VDD.n215 0.001
R740 VDD.n218 VDD.n217 0.001
R741 VDD.n220 VDD.n219 0.001
R742 VDD.n222 VDD.n221 0.001
R743 VDD.n224 VDD.n223 0.001
R744 VDD.n226 VDD.n225 0.001
R745 VDD.n228 VDD.n227 0.001
R746 VDD.n230 VDD.n229 0.001
R747 VDD.n232 VDD.n231 0.001
R748 VDD.n234 VDD.n233 0.001
R749 VDD.n236 VDD.n235 0.001
R750 VDD.n238 VDD.n237 0.001
R751 VDD.n239 VDD.n204 0.001
R752 VDD.t6 VDD.n120 0.001
R753 VDD.t4 VDD.n120 0.001
R754 VDD.n209 VDD.n207 0.001
R755 VDD.n211 VDD.n210 0.001
R756 VDD.n213 VDD.n212 0.001
R757 VDD.n215 VDD.n214 0.001
R758 VDD.n217 VDD.n216 0.001
R759 VDD.n219 VDD.n218 0.001
R760 VDD.n221 VDD.n220 0.001
R761 VDD.n223 VDD.n222 0.001
R762 VDD.n225 VDD.n224 0.001
R763 VDD.n227 VDD.n226 0.001
R764 VDD.n229 VDD.n228 0.001
R765 VDD.n231 VDD.n230 0.001
R766 VDD.n233 VDD.n232 0.001
R767 VDD.n235 VDD.n234 0.001
R768 VDD.n237 VDD.n236 0.001
R769 VDD.n239 VDD.n238 0.001
R770 VDD.n278 VDD.n204 0.001
R771 VDD.n487 VDD.n5 0.001
R772 VDD.n71 VDD.n58 0.001
R773 VDD.n72 VDD.n55 0.001
R774 VDD.n73 VDD.n52 0.001
R775 VDD.n74 VDD.n49 0.001
R776 VDD.n75 VDD.n46 0.001
R777 VDD.n76 VDD.n43 0.001
R778 VDD.n77 VDD.n40 0.001
R779 VDD.n78 VDD.n37 0.001
R780 VDD.t3 VDD.n34 0.001
R781 VDD.n79 VDD.n31 0.001
R782 VDD.n80 VDD.n28 0.001
R783 VDD.n81 VDD.n25 0.001
R784 VDD.n82 VDD.n22 0.001
R785 VDD.n83 VDD.n19 0.001
R786 VDD.n84 VDD.n16 0.001
R787 VDD.n85 VDD.n13 0.001
R788 VDD.n458 VDD.n10 0.001
R789 VDD.n394 VDD.n7 0.001
R790 VDD.n100 VDD.n97 0.001
R791 VDD.n319 VDD.n101 0.001
R792 VDD.n317 VDD.n102 0.001
R793 VDD.n315 VDD.n103 0.001
R794 VDD.n313 VDD.n104 0.001
R795 VDD.n311 VDD.n105 0.001
R796 VDD.n309 VDD.n106 0.001
R797 VDD.n307 VDD.n107 0.001
R798 VDD.n305 VDD.t5 0.001
R799 VDD.n303 VDD.n108 0.001
R800 VDD.n301 VDD.n109 0.001
R801 VDD.n299 VDD.n110 0.001
R802 VDD.n297 VDD.n111 0.001
R803 VDD.n295 VDD.n112 0.001
R804 VDD.n293 VDD.n113 0.001
R805 VDD.n291 VDD.n114 0.001
R806 VDD.n289 VDD.n115 0.001
R807 VDD.n288 VDD.n118 0.001
R808 VDD.t4 VDD.n122 0.001
R809 VDD.n122 VDD.n118 0.001
R810 VDD.n288 VDD.n115 0.001
R811 VDD.n289 VDD.n114 0.001
R812 VDD.n291 VDD.n113 0.001
R813 VDD.n293 VDD.n112 0.001
R814 VDD.n295 VDD.n111 0.001
R815 VDD.n297 VDD.n110 0.001
R816 VDD.n299 VDD.n109 0.001
R817 VDD.n301 VDD.n108 0.001
R818 VDD.n303 VDD.t5 0.001
R819 VDD.n305 VDD.n107 0.001
R820 VDD.n307 VDD.n106 0.001
R821 VDD.n309 VDD.n105 0.001
R822 VDD.n311 VDD.n104 0.001
R823 VDD.n313 VDD.n103 0.001
R824 VDD.n315 VDD.n102 0.001
R825 VDD.n317 VDD.n101 0.001
R826 VDD.n319 VDD.n100 0.001
R827 VDD.n394 VDD.n97 0.001
R828 VDD.n458 VDD.n7 0.001
R829 VDD.n85 VDD.n10 0.001
R830 VDD.n84 VDD.n13 0.001
R831 VDD.n83 VDD.n16 0.001
R832 VDD.n82 VDD.n19 0.001
R833 VDD.n81 VDD.n22 0.001
R834 VDD.n80 VDD.n25 0.001
R835 VDD.n79 VDD.n28 0.001
R836 VDD.t3 VDD.n31 0.001
R837 VDD.n78 VDD.n34 0.001
R838 VDD.n77 VDD.n37 0.001
R839 VDD.n76 VDD.n40 0.001
R840 VDD.n75 VDD.n43 0.001
R841 VDD.n74 VDD.n46 0.001
R842 VDD.n73 VDD.n49 0.001
R843 VDD.n72 VDD.n52 0.001
R844 VDD.n71 VDD.n55 0.001
R845 VDD.n58 VDD.n5 0.001
R846 VDD.t0 VDD.n487 0.001
R847 VDD.n464 VDD.n86 0.001
R848 VDD.n464 VDD.n69 0.001
R849 VDD.n469 VDD.n468 0.001
R850 VDD.n471 VDD.n470 0.001
R851 VDD.n474 VDD.n67 0.001
R852 VDD.n476 VDD.n475 0.001
R853 VDD.n478 VDD.n477 0.001
R854 VDD.n459 VDD.n457 0.001
R855 VDD.n455 VDD.n454 0.001
R856 VDD.n452 VDD.n451 0.001
R857 VDD.n449 VDD.n448 0.001
R858 VDD.n446 VDD.n445 0.001
R859 VDD.n443 VDD.n442 0.001
R860 VDD.n440 VDD.n439 0.001
R861 VDD.n437 VDD.n436 0.001
R862 VDD.n434 VDD.n433 0.001
R863 VDD.n431 VDD.n430 0.001
R864 VDD.n428 VDD.n427 0.001
R865 VDD.n425 VDD.n424 0.001
R866 VDD.n422 VDD.n421 0.001
R867 VDD.n419 VDD.n418 0.001
R868 VDD.n416 VDD.n415 0.001
R869 VDD.n413 VDD.n412 0.001
R870 VDD.n483 VDD.n63 0.001
R871 VDD.n482 VDD.n481 0.001
R872 VDD.n392 VDD.n391 0.001
R873 VDD.n393 VDD.n392 0.001
R874 VDD.n369 VDD.n90 0.001
R875 VDD.n371 VDD.n91 0.001
R876 VDD.n373 VDD.n92 0.001
R877 VDD.n375 VDD.n93 0.001
R878 VDD.n377 VDD.n94 0.001
R879 VDD.n379 VDD.n95 0.001
R880 VDD.n129 VDD.n128 0.001
R881 VDD.n134 VDD.n127 0.001
R882 VDD.n135 VDD.n126 0.001
R883 VDD.n136 VDD.n125 0.001
R884 VDD.n137 VDD.n124 0.001
R885 VDD.n138 VDD.n123 0.001
R886 VDD.n390 VDD.n389 0.001
R887 VDD.n388 VDD.n387 0.001
R888 VDD.n321 VDD.n131 0.001
R889 VDD.n324 VDD.n322 0.001
R890 VDD.n327 VDD.n325 0.001
R891 VDD.n330 VDD.n328 0.001
R892 VDD.n333 VDD.n331 0.001
R893 VDD.n336 VDD.n334 0.001
R894 VDD.n339 VDD.n337 0.001
R895 VDD.n342 VDD.n340 0.001
R896 VDD.n345 VDD.n343 0.001
R897 VDD.n348 VDD.n346 0.001
R898 VDD.n351 VDD.n349 0.001
R899 VDD.n354 VDD.n352 0.001
R900 VDD.n357 VDD.n355 0.001
R901 VDD.n360 VDD.n358 0.001
R902 VDD.n363 VDD.n361 0.001
R903 VDD.n365 VDD.n364 0.001
R904 VDD.n367 VDD.n366 0.001
R905 VDD.n367 VDD.n96 0.001
R906 VSS.n432 VSS.n431 713.5
R907 VSS.n486 VSS.n91 701.389
R908 VSS.n477 VSS.n152 681.91
R909 VSS.n482 VSS.n481 670.619
R910 VSS.t4 VSS.n79 270.003
R911 VSS.n90 VSS.n79 191.556
R912 VSS.n90 VSS.t2 78.0239
R913 VSS.n91 VSS.n90 71.7258
R914 VSS.n62 VSS.t9 69.8566
R915 VSS.n183 VSS.t1 69.8566
R916 VSS.n281 VSS.t0 69.827
R917 VSS.t7 VSS.n362 62.2096
R918 VSS.n388 VSS.t7 59.6704
R919 VSS.t9 VSS.n23 57.1555
R920 VSS.t1 VSS.n138 57.1555
R921 VSS.t0 VSS.n242 57.1313
R922 VSS.n90 VSS.n89 43.7635
R923 VSS.n80 VSS.t4 27.7377
R924 VSS.n88 VSS.t2 27.7352
R925 VSS.n361 VSS.n343 24.3947
R926 VSS.n363 VSS.n341 24.3947
R927 VSS.n347 VSS.n340 24.3947
R928 VSS.n363 VSS.n340 24.3947
R929 VSS.n361 VSS.n342 24.3947
R930 VSS.n343 VSS.n337 24.3947
R931 VSS.n484 VSS.n116 17.0005
R932 VSS.n484 VSS.n23 17.0005
R933 VSS.n479 VSS.n146 17.0005
R934 VSS.n479 VSS.n138 17.0005
R935 VSS.n434 VSS.n314 17.0005
R936 VSS.n434 VSS.n242 17.0005
R937 VSS.n422 VSS.n388 17.0005
R938 VSS.n422 VSS.n362 17.0005
R939 VSS.n188 VSS.n3 17.0005
R940 VSS.n490 VSS.n3 17.0005
R941 VSS.n476 VSS.n181 17.0005
R942 VSS.n476 VSS.n475 17.0005
R943 VSS.n401 VSS.n221 17.0005
R944 VSS.n445 VSS.n221 17.0005
R945 VSS.n488 VSS.n44 17.0005
R946 VSS.n488 VSS.n51 17.0005
R947 VSS.n488 VSS.n41 17.0005
R948 VSS.n488 VSS.n53 17.0005
R949 VSS.n488 VSS.n38 17.0005
R950 VSS.n488 VSS.n55 17.0005
R951 VSS.n488 VSS.n35 17.0005
R952 VSS.n488 VSS.n57 17.0005
R953 VSS.n488 VSS.n32 17.0005
R954 VSS.n488 VSS.n59 17.0005
R955 VSS.n488 VSS.n29 17.0005
R956 VSS.n488 VSS.n61 17.0005
R957 VSS.n488 VSS.n26 17.0005
R958 VSS.n488 VSS.n62 17.0005
R959 VSS.n488 VSS.n23 17.0005
R960 VSS.n488 VSS.n64 17.0005
R961 VSS.n488 VSS.n20 17.0005
R962 VSS.n488 VSS.n66 17.0005
R963 VSS.n488 VSS.n17 17.0005
R964 VSS.n488 VSS.n68 17.0005
R965 VSS.n488 VSS.n14 17.0005
R966 VSS.n488 VSS.n70 17.0005
R967 VSS.n488 VSS.n11 17.0005
R968 VSS.n488 VSS.n72 17.0005
R969 VSS.n488 VSS.n8 17.0005
R970 VSS.n488 VSS.n74 17.0005
R971 VSS.n488 VSS.n6 17.0005
R972 VSS.n488 VSS.n76 17.0005
R973 VSS.n488 VSS.n5 17.0005
R974 VSS.n473 VSS.n217 17.0005
R975 VSS.n473 VSS.n454 17.0005
R976 VSS.n473 VSS.n215 17.0005
R977 VSS.n473 VSS.n455 17.0005
R978 VSS.n473 VSS.n213 17.0005
R979 VSS.n473 VSS.n456 17.0005
R980 VSS.n473 VSS.n211 17.0005
R981 VSS.n473 VSS.n457 17.0005
R982 VSS.n473 VSS.n209 17.0005
R983 VSS.n473 VSS.n458 17.0005
R984 VSS.n473 VSS.n207 17.0005
R985 VSS.n473 VSS.n459 17.0005
R986 VSS.n473 VSS.n205 17.0005
R987 VSS.n473 VSS.n183 17.0005
R988 VSS.n473 VSS.n138 17.0005
R989 VSS.n473 VSS.n460 17.0005
R990 VSS.n473 VSS.n202 17.0005
R991 VSS.n473 VSS.n461 17.0005
R992 VSS.n473 VSS.n200 17.0005
R993 VSS.n473 VSS.n462 17.0005
R994 VSS.n473 VSS.n198 17.0005
R995 VSS.n473 VSS.n463 17.0005
R996 VSS.n473 VSS.n196 17.0005
R997 VSS.n473 VSS.n464 17.0005
R998 VSS.n473 VSS.n194 17.0005
R999 VSS.n473 VSS.n465 17.0005
R1000 VSS.n473 VSS.n192 17.0005
R1001 VSS.n473 VSS.n466 17.0005
R1002 VSS.n473 VSS.n191 17.0005
R1003 VSS.n443 VSS.n263 17.0005
R1004 VSS.n443 VSS.n270 17.0005
R1005 VSS.n443 VSS.n260 17.0005
R1006 VSS.n443 VSS.n272 17.0005
R1007 VSS.n443 VSS.n257 17.0005
R1008 VSS.n443 VSS.n274 17.0005
R1009 VSS.n443 VSS.n254 17.0005
R1010 VSS.n443 VSS.n276 17.0005
R1011 VSS.n443 VSS.n251 17.0005
R1012 VSS.n443 VSS.n278 17.0005
R1013 VSS.n443 VSS.n248 17.0005
R1014 VSS.n443 VSS.n280 17.0005
R1015 VSS.n443 VSS.n245 17.0005
R1016 VSS.n443 VSS.n281 17.0005
R1017 VSS.n443 VSS.n242 17.0005
R1018 VSS.n443 VSS.n283 17.0005
R1019 VSS.n443 VSS.n239 17.0005
R1020 VSS.n443 VSS.n285 17.0005
R1021 VSS.n443 VSS.n236 17.0005
R1022 VSS.n443 VSS.n287 17.0005
R1023 VSS.n443 VSS.n233 17.0005
R1024 VSS.n443 VSS.n289 17.0005
R1025 VSS.n443 VSS.n230 17.0005
R1026 VSS.n443 VSS.n291 17.0005
R1027 VSS.n443 VSS.n227 17.0005
R1028 VSS.n443 VSS.n293 17.0005
R1029 VSS.n443 VSS.n225 17.0005
R1030 VSS.n443 VSS.n295 17.0005
R1031 VSS.n443 VSS.n224 17.0005
R1032 VSS.n101 VSS.n76 12.199
R1033 VSS.n102 VSS.n74 12.199
R1034 VSS.n103 VSS.n72 12.199
R1035 VSS.n104 VSS.n70 12.199
R1036 VSS.n105 VSS.n68 12.199
R1037 VSS.n106 VSS.n66 12.199
R1038 VSS.n107 VSS.n64 12.199
R1039 VSS.n108 VSS.n62 12.199
R1040 VSS.n109 VSS.n61 12.199
R1041 VSS.n110 VSS.n59 12.199
R1042 VSS.n111 VSS.n57 12.199
R1043 VSS.n112 VSS.n55 12.199
R1044 VSS.n113 VSS.n53 12.199
R1045 VSS.n114 VSS.n51 12.199
R1046 VSS.n482 VSS.n49 12.199
R1047 VSS.n466 VSS.n131 12.199
R1048 VSS.n465 VSS.n132 12.199
R1049 VSS.n464 VSS.n133 12.199
R1050 VSS.n463 VSS.n134 12.199
R1051 VSS.n462 VSS.n135 12.199
R1052 VSS.n461 VSS.n136 12.199
R1053 VSS.n460 VSS.n137 12.199
R1054 VSS.n183 VSS.n139 12.199
R1055 VSS.n459 VSS.n140 12.199
R1056 VSS.n458 VSS.n141 12.199
R1057 VSS.n457 VSS.n142 12.199
R1058 VSS.n456 VSS.n143 12.199
R1059 VSS.n455 VSS.n144 12.199
R1060 VSS.n454 VSS.n145 12.199
R1061 VSS.n477 VSS.n148 12.199
R1062 VSS.n114 VSS.n44 12.199
R1063 VSS.n113 VSS.n41 12.199
R1064 VSS.n112 VSS.n38 12.199
R1065 VSS.n111 VSS.n35 12.199
R1066 VSS.n110 VSS.n32 12.199
R1067 VSS.n109 VSS.n29 12.199
R1068 VSS.n108 VSS.n26 12.199
R1069 VSS.n107 VSS.n20 12.199
R1070 VSS.n106 VSS.n17 12.199
R1071 VSS.n105 VSS.n14 12.199
R1072 VSS.n104 VSS.n11 12.199
R1073 VSS.n103 VSS.n8 12.199
R1074 VSS.n102 VSS.n6 12.199
R1075 VSS.n101 VSS.n5 12.199
R1076 VSS.n217 VSS.n145 12.199
R1077 VSS.n215 VSS.n144 12.199
R1078 VSS.n213 VSS.n143 12.199
R1079 VSS.n211 VSS.n142 12.199
R1080 VSS.n209 VSS.n141 12.199
R1081 VSS.n207 VSS.n140 12.199
R1082 VSS.n205 VSS.n139 12.199
R1083 VSS.n202 VSS.n137 12.199
R1084 VSS.n200 VSS.n136 12.199
R1085 VSS.n198 VSS.n135 12.199
R1086 VSS.n196 VSS.n134 12.199
R1087 VSS.n194 VSS.n133 12.199
R1088 VSS.n192 VSS.n132 12.199
R1089 VSS.n191 VSS.n131 12.199
R1090 VSS.n116 VSS.n49 12.199
R1091 VSS.n148 VSS.n146 12.199
R1092 VSS.n299 VSS.n295 12.1976
R1093 VSS.n300 VSS.n293 12.1976
R1094 VSS.n301 VSS.n291 12.1976
R1095 VSS.n302 VSS.n289 12.1976
R1096 VSS.n303 VSS.n287 12.1976
R1097 VSS.n304 VSS.n285 12.1976
R1098 VSS.n305 VSS.n283 12.1976
R1099 VSS.n306 VSS.n281 12.1976
R1100 VSS.n307 VSS.n280 12.1976
R1101 VSS.n308 VSS.n278 12.1976
R1102 VSS.n309 VSS.n276 12.1976
R1103 VSS.n310 VSS.n274 12.1976
R1104 VSS.n311 VSS.n272 12.1976
R1105 VSS.n312 VSS.n270 12.1976
R1106 VSS.n432 VSS.n268 12.1976
R1107 VSS.n431 VSS.n337 12.1976
R1108 VSS.n362 VSS.n342 12.1976
R1109 VSS.n424 VSS.n347 12.1976
R1110 VSS.n312 VSS.n263 12.1976
R1111 VSS.n311 VSS.n260 12.1976
R1112 VSS.n310 VSS.n257 12.1976
R1113 VSS.n309 VSS.n254 12.1976
R1114 VSS.n308 VSS.n251 12.1976
R1115 VSS.n307 VSS.n248 12.1976
R1116 VSS.n306 VSS.n245 12.1976
R1117 VSS.n305 VSS.n239 12.1976
R1118 VSS.n304 VSS.n236 12.1976
R1119 VSS.n303 VSS.n233 12.1976
R1120 VSS.n302 VSS.n230 12.1976
R1121 VSS.n301 VSS.n227 12.1976
R1122 VSS.n300 VSS.n225 12.1976
R1123 VSS.n299 VSS.n224 12.1976
R1124 VSS.n388 VSS.n341 12.1976
R1125 VSS.n314 VSS.n268 12.1976
R1126 VSS VSS.n492 9.2997
R1127 VSS.n486 VSS.n92 8.501
R1128 VSS.n486 VSS.n93 8.501
R1129 VSS.n482 VSS.n47 8.501
R1130 VSS.n482 VSS.n124 8.501
R1131 VSS.n482 VSS.n118 8.501
R1132 VSS.n481 VSS.n125 8.501
R1133 VSS.n481 VSS.n126 8.501
R1134 VSS.n477 VSS.n151 8.501
R1135 VSS.n477 VSS.n150 8.501
R1136 VSS.n477 VSS.n149 8.501
R1137 VSS.n437 VSS.n152 8.501
R1138 VSS.n296 VSS.n152 8.501
R1139 VSS.n432 VSS.n266 8.501
R1140 VSS.n432 VSS.n322 8.501
R1141 VSS.n432 VSS.n316 8.501
R1142 VSS.n424 VSS.n423 8.501
R1143 VSS.n424 VSS.n359 8.501
R1144 VSS.n424 VSS.n358 8.501
R1145 VSS.n424 VSS.n357 8.501
R1146 VSS.n424 VSS.n356 8.501
R1147 VSS.n424 VSS.n355 8.501
R1148 VSS.n424 VSS.n354 8.501
R1149 VSS.n424 VSS.n353 8.501
R1150 VSS.n424 VSS.n352 8.501
R1151 VSS.n424 VSS.n351 8.501
R1152 VSS.n424 VSS.n350 8.501
R1153 VSS.n424 VSS.n349 8.501
R1154 VSS.n424 VSS.n348 8.501
R1155 VSS.n425 VSS.n424 8.501
R1156 VSS.n431 VSS.n323 8.501
R1157 VSS.n431 VSS.n324 8.501
R1158 VSS.n431 VSS.n325 8.501
R1159 VSS.n431 VSS.n326 8.501
R1160 VSS.n431 VSS.n327 8.501
R1161 VSS.n431 VSS.n328 8.501
R1162 VSS.n431 VSS.n329 8.501
R1163 VSS.n431 VSS.n330 8.501
R1164 VSS.n431 VSS.n331 8.501
R1165 VSS.n431 VSS.n332 8.501
R1166 VSS.n431 VSS.n333 8.501
R1167 VSS.n431 VSS.n334 8.501
R1168 VSS.n431 VSS.n335 8.501
R1169 VSS.n431 VSS.n336 8.501
R1170 VSS.n62 VSS.n3 8.5005
R1171 VSS.n476 VSS.n183 8.5005
R1172 VSS.n281 VSS.n221 8.5005
R1173 VSS.n45 VSS.n3 8.49273
R1174 VSS.n42 VSS.n3 8.49273
R1175 VSS.n39 VSS.n3 8.49273
R1176 VSS.n36 VSS.n3 8.49273
R1177 VSS.n33 VSS.n3 8.49273
R1178 VSS.n30 VSS.n3 8.49273
R1179 VSS.n27 VSS.n3 8.49273
R1180 VSS.n24 VSS.n3 8.49273
R1181 VSS.n21 VSS.n3 8.49273
R1182 VSS.n18 VSS.n3 8.49273
R1183 VSS.n15 VSS.n3 8.49273
R1184 VSS.n12 VSS.n3 8.49273
R1185 VSS.n9 VSS.n3 8.49273
R1186 VSS.n4 VSS.n3 8.49273
R1187 VSS.n476 VSS.n179 8.49273
R1188 VSS.n476 VSS.n177 8.49273
R1189 VSS.n476 VSS.n175 8.49273
R1190 VSS.n476 VSS.n173 8.49273
R1191 VSS.n476 VSS.n171 8.49273
R1192 VSS.n476 VSS.n169 8.49273
R1193 VSS.n476 VSS.n167 8.49273
R1194 VSS.n476 VSS.n165 8.49273
R1195 VSS.n476 VSS.n163 8.49273
R1196 VSS.n476 VSS.n161 8.49273
R1197 VSS.n476 VSS.n159 8.49273
R1198 VSS.n476 VSS.n157 8.49273
R1199 VSS.n476 VSS.n155 8.49273
R1200 VSS.n476 VSS.n154 8.49273
R1201 VSS.n264 VSS.n221 8.49273
R1202 VSS.n261 VSS.n221 8.49273
R1203 VSS.n258 VSS.n221 8.49273
R1204 VSS.n255 VSS.n221 8.49273
R1205 VSS.n252 VSS.n221 8.49273
R1206 VSS.n249 VSS.n221 8.49273
R1207 VSS.n246 VSS.n221 8.49273
R1208 VSS.n243 VSS.n221 8.49273
R1209 VSS.n240 VSS.n221 8.49273
R1210 VSS.n237 VSS.n221 8.49273
R1211 VSS.n234 VSS.n221 8.49273
R1212 VSS.n231 VSS.n221 8.49273
R1213 VSS.n228 VSS.n221 8.49273
R1214 VSS.n222 VSS.n221 8.49273
R1215 VSS.n488 VSS.n46 8.49273
R1216 VSS.n488 VSS.n43 8.49273
R1217 VSS.n488 VSS.n40 8.49273
R1218 VSS.n488 VSS.n37 8.49273
R1219 VSS.n488 VSS.n34 8.49273
R1220 VSS.n488 VSS.n31 8.49273
R1221 VSS.n488 VSS.n28 8.49273
R1222 VSS.n488 VSS.n22 8.49273
R1223 VSS.n488 VSS.n19 8.49273
R1224 VSS.n488 VSS.n16 8.49273
R1225 VSS.n488 VSS.n13 8.49273
R1226 VSS.n488 VSS.n10 8.49273
R1227 VSS.n488 VSS.n7 8.49273
R1228 VSS.n489 VSS.n488 8.49273
R1229 VSS.n473 VSS.n218 8.49273
R1230 VSS.n473 VSS.n216 8.49273
R1231 VSS.n473 VSS.n214 8.49273
R1232 VSS.n473 VSS.n212 8.49273
R1233 VSS.n473 VSS.n210 8.49273
R1234 VSS.n473 VSS.n208 8.49273
R1235 VSS.n473 VSS.n206 8.49273
R1236 VSS.n473 VSS.n203 8.49273
R1237 VSS.n473 VSS.n201 8.49273
R1238 VSS.n473 VSS.n199 8.49273
R1239 VSS.n473 VSS.n197 8.49273
R1240 VSS.n473 VSS.n195 8.49273
R1241 VSS.n473 VSS.n193 8.49273
R1242 VSS.n474 VSS.n473 8.49273
R1243 VSS.n443 VSS.n265 8.49273
R1244 VSS.n443 VSS.n262 8.49273
R1245 VSS.n443 VSS.n259 8.49273
R1246 VSS.n443 VSS.n256 8.49273
R1247 VSS.n443 VSS.n253 8.49273
R1248 VSS.n443 VSS.n250 8.49273
R1249 VSS.n443 VSS.n247 8.49273
R1250 VSS.n443 VSS.n241 8.49273
R1251 VSS.n443 VSS.n238 8.49273
R1252 VSS.n443 VSS.n235 8.49273
R1253 VSS.n443 VSS.n232 8.49273
R1254 VSS.n443 VSS.n229 8.49273
R1255 VSS.n443 VSS.n226 8.49273
R1256 VSS.n444 VSS.n443 8.49273
R1257 VSS.n488 VSS.n25 8.48885
R1258 VSS.n473 VSS.n204 8.48885
R1259 VSS.n443 VSS.n244 8.48885
R1260 VSS.n488 VSS.n48 8.48362
R1261 VSS.n473 VSS.n453 8.48362
R1262 VSS.n443 VSS.n267 8.48362
R1263 VSS.n488 VSS.n1 8.48362
R1264 VSS.n473 VSS.n472 8.48362
R1265 VSS.n443 VSS.n219 8.48362
R1266 VSS.n99 VSS.n95 8.46995
R1267 VSS.n97 VSS.n77 8.46995
R1268 VSS.n123 VSS.n122 8.46995
R1269 VSS.n120 VSS.n117 8.46995
R1270 VSS.n467 VSS.n129 8.46995
R1271 VSS.n471 VSS.n470 8.46995
R1272 VSS.n452 VSS.n448 8.46995
R1273 VSS.n450 VSS.n147 8.46995
R1274 VSS.n82 VSS.n78 8.46995
R1275 VSS.n436 VSS.n297 8.46995
R1276 VSS.n441 VSS.n440 8.46995
R1277 VSS.n321 VSS.n320 8.46995
R1278 VSS.n318 VSS.n315 8.46995
R1279 VSS.n386 VSS.n360 8.46995
R1280 VSS.n385 VSS.n364 8.46995
R1281 VSS.n384 VSS.n365 8.46995
R1282 VSS.n383 VSS.n366 8.46995
R1283 VSS.n382 VSS.n367 8.46995
R1284 VSS.n381 VSS.n368 8.46995
R1285 VSS.n380 VSS.n369 8.46995
R1286 VSS.n379 VSS.n370 8.46995
R1287 VSS.n378 VSS.n371 8.46995
R1288 VSS.n377 VSS.n372 8.46995
R1289 VSS.n376 VSS.n373 8.46995
R1290 VSS.n375 VSS.n374 8.46995
R1291 VSS.n346 VSS.n345 8.46995
R1292 VSS.n427 VSS.n426 8.46995
R1293 VSS.n344 VSS.n338 8.46995
R1294 VSS.n390 VSS.n389 8.46995
R1295 VSS.n392 VSS.n391 8.46995
R1296 VSS.n394 VSS.n393 8.46995
R1297 VSS.n396 VSS.n395 8.46995
R1298 VSS.n398 VSS.n397 8.46995
R1299 VSS.n405 VSS.n404 8.46995
R1300 VSS.n407 VSS.n406 8.46995
R1301 VSS.n409 VSS.n408 8.46995
R1302 VSS.n411 VSS.n410 8.46995
R1303 VSS.n413 VSS.n412 8.46995
R1304 VSS.n415 VSS.n414 8.46995
R1305 VSS.n417 VSS.n416 8.46995
R1306 VSS.n419 VSS.n418 8.46995
R1307 VSS.n98 VSS.n96 8.45723
R1308 VSS.n121 VSS.n119 8.45723
R1309 VSS.n469 VSS.n468 8.45723
R1310 VSS.n451 VSS.n449 8.45723
R1311 VSS.n439 VSS.n438 8.45723
R1312 VSS.n319 VSS.n317 8.45723
R1313 VSS.n94 VSS.n5 7.60345
R1314 VSS.n191 VSS.n128 7.60345
R1315 VSS.n224 VSS.n223 7.60311
R1316 VSS.n115 VSS.n44 7.10396
R1317 VSS.n50 VSS.n41 7.10396
R1318 VSS.n52 VSS.n38 7.10396
R1319 VSS.n54 VSS.n35 7.10396
R1320 VSS.n56 VSS.n32 7.10396
R1321 VSS.n58 VSS.n29 7.10396
R1322 VSS.n60 VSS.n26 7.10396
R1323 VSS.n64 VSS.n63 7.10396
R1324 VSS.n66 VSS.n65 7.10396
R1325 VSS.n68 VSS.n67 7.10396
R1326 VSS.n70 VSS.n69 7.10396
R1327 VSS.n72 VSS.n71 7.10396
R1328 VSS.n74 VSS.n73 7.10396
R1329 VSS.n76 VSS.n75 7.10396
R1330 VSS.n217 VSS.n180 7.10396
R1331 VSS.n215 VSS.n178 7.10396
R1332 VSS.n213 VSS.n176 7.10396
R1333 VSS.n211 VSS.n174 7.10396
R1334 VSS.n209 VSS.n172 7.10396
R1335 VSS.n207 VSS.n170 7.10396
R1336 VSS.n205 VSS.n168 7.10396
R1337 VSS.n460 VSS.n166 7.10396
R1338 VSS.n461 VSS.n164 7.10396
R1339 VSS.n462 VSS.n162 7.10396
R1340 VSS.n463 VSS.n160 7.10396
R1341 VSS.n464 VSS.n158 7.10396
R1342 VSS.n465 VSS.n156 7.10396
R1343 VSS.n466 VSS.n153 7.10396
R1344 VSS.n313 VSS.n263 7.10346
R1345 VSS.n269 VSS.n260 7.10346
R1346 VSS.n271 VSS.n257 7.10346
R1347 VSS.n273 VSS.n254 7.10346
R1348 VSS.n275 VSS.n251 7.10346
R1349 VSS.n277 VSS.n248 7.10346
R1350 VSS.n279 VSS.n245 7.10346
R1351 VSS.n283 VSS.n282 7.10346
R1352 VSS.n285 VSS.n284 7.10346
R1353 VSS.n287 VSS.n286 7.10346
R1354 VSS.n289 VSS.n288 7.10346
R1355 VSS.n291 VSS.n290 7.10346
R1356 VSS.n293 VSS.n292 7.10346
R1357 VSS.n295 VSS.n294 7.10346
R1358 VSS.n116 VSS.n115 7.10329
R1359 VSS.n51 VSS.n50 7.10329
R1360 VSS.n53 VSS.n52 7.10329
R1361 VSS.n55 VSS.n54 7.10329
R1362 VSS.n57 VSS.n56 7.10329
R1363 VSS.n59 VSS.n58 7.10329
R1364 VSS.n61 VSS.n60 7.10329
R1365 VSS.n63 VSS.n23 7.10329
R1366 VSS.n65 VSS.n20 7.10329
R1367 VSS.n67 VSS.n17 7.10329
R1368 VSS.n69 VSS.n14 7.10329
R1369 VSS.n71 VSS.n11 7.10329
R1370 VSS.n73 VSS.n8 7.10329
R1371 VSS.n75 VSS.n6 7.10329
R1372 VSS.n180 VSS.n146 7.10329
R1373 VSS.n454 VSS.n178 7.10329
R1374 VSS.n455 VSS.n176 7.10329
R1375 VSS.n456 VSS.n174 7.10329
R1376 VSS.n457 VSS.n172 7.10329
R1377 VSS.n458 VSS.n170 7.10329
R1378 VSS.n459 VSS.n168 7.10329
R1379 VSS.n166 VSS.n138 7.10329
R1380 VSS.n202 VSS.n164 7.10329
R1381 VSS.n200 VSS.n162 7.10329
R1382 VSS.n198 VSS.n160 7.10329
R1383 VSS.n196 VSS.n158 7.10329
R1384 VSS.n194 VSS.n156 7.10329
R1385 VSS.n192 VSS.n153 7.10329
R1386 VSS.n314 VSS.n313 7.10279
R1387 VSS.n270 VSS.n269 7.10279
R1388 VSS.n272 VSS.n271 7.10279
R1389 VSS.n274 VSS.n273 7.10279
R1390 VSS.n276 VSS.n275 7.10279
R1391 VSS.n278 VSS.n277 7.10279
R1392 VSS.n280 VSS.n279 7.10279
R1393 VSS.n282 VSS.n242 7.10279
R1394 VSS.n284 VSS.n239 7.10279
R1395 VSS.n286 VSS.n236 7.10279
R1396 VSS.n288 VSS.n233 7.10279
R1397 VSS.n290 VSS.n230 7.10279
R1398 VSS.n292 VSS.n227 7.10279
R1399 VSS.n294 VSS.n225 7.10279
R1400 VSS.n487 VSS.n486 5.66778
R1401 VSS.n481 VSS.n127 5.66778
R1402 VSS.n442 VSS.n152 5.66778
R1403 VSS.n486 VSS.n485 5.66767
R1404 VSS.n483 VSS.n482 5.66767
R1405 VSS.n481 VSS.n480 5.66767
R1406 VSS.n478 VSS.n477 5.66767
R1407 VSS.n435 VSS.n152 5.66767
R1408 VSS.n433 VSS.n432 5.66767
R1409 VSS.n424 VSS.n339 5.66767
R1410 VSS.n431 VSS.n430 5.66767
R1411 VSS.n399 VSS.t6 5.0595
R1412 VSS.n184 VSS.t11 5.0595
R1413 VSS.n186 VSS.t10 5.0595
R1414 VSS.n85 VSS.t3 5.03887
R1415 VSS.n83 VSS.t5 5.03887
R1416 VSS.n420 VSS.t8 4.66164
R1417 VSS.n86 VSS.n78 4.17416
R1418 VSS.n84 VSS.n78 4.14781
R1419 VSS.n492 VSS.n0 4.01206
R1420 VSS.n422 VSS.n421 2.72439
R1421 VSS.n422 VSS.n387 2.72439
R1422 VSS.n434 VSS.n312 2.40271
R1423 VSS.n434 VSS.n311 2.40271
R1424 VSS.n434 VSS.n310 2.40271
R1425 VSS.n434 VSS.n309 2.40271
R1426 VSS.n434 VSS.n308 2.40271
R1427 VSS.n434 VSS.n307 2.40271
R1428 VSS.n434 VSS.n306 2.40271
R1429 VSS.n434 VSS.n305 2.40271
R1430 VSS.n434 VSS.n304 2.40271
R1431 VSS.n434 VSS.n303 2.40271
R1432 VSS.n434 VSS.n302 2.40271
R1433 VSS.n434 VSS.n301 2.40271
R1434 VSS.n434 VSS.n300 2.40271
R1435 VSS.n434 VSS.n299 2.40271
R1436 VSS.n429 VSS.n340 2.40271
R1437 VSS.n429 VSS.n341 2.40271
R1438 VSS.n429 VSS.n342 2.40271
R1439 VSS.n429 VSS.n343 2.40271
R1440 VSS.n422 VSS.n347 2.40271
R1441 VSS.n422 VSS.n363 2.40271
R1442 VSS.n422 VSS.n361 2.40271
R1443 VSS.n422 VSS.n337 2.40271
R1444 VSS.n443 VSS.n268 2.40271
R1445 VSS.n484 VSS.n114 2.40198
R1446 VSS.n484 VSS.n113 2.40198
R1447 VSS.n484 VSS.n112 2.40198
R1448 VSS.n484 VSS.n111 2.40198
R1449 VSS.n484 VSS.n110 2.40198
R1450 VSS.n484 VSS.n109 2.40198
R1451 VSS.n484 VSS.n108 2.40198
R1452 VSS.n484 VSS.n107 2.40198
R1453 VSS.n484 VSS.n106 2.40198
R1454 VSS.n484 VSS.n105 2.40198
R1455 VSS.n484 VSS.n104 2.40198
R1456 VSS.n484 VSS.n103 2.40198
R1457 VSS.n484 VSS.n102 2.40198
R1458 VSS.n484 VSS.n101 2.40198
R1459 VSS.n479 VSS.n145 2.40198
R1460 VSS.n479 VSS.n144 2.40198
R1461 VSS.n479 VSS.n143 2.40198
R1462 VSS.n479 VSS.n142 2.40198
R1463 VSS.n479 VSS.n141 2.40198
R1464 VSS.n479 VSS.n140 2.40198
R1465 VSS.n479 VSS.n139 2.40198
R1466 VSS.n479 VSS.n137 2.40198
R1467 VSS.n479 VSS.n136 2.40198
R1468 VSS.n479 VSS.n135 2.40198
R1469 VSS.n479 VSS.n134 2.40198
R1470 VSS.n479 VSS.n133 2.40198
R1471 VSS.n479 VSS.n132 2.40198
R1472 VSS.n479 VSS.n131 2.40198
R1473 VSS.n488 VSS.n49 2.40198
R1474 VSS.n473 VSS.n148 2.40198
R1475 VSS.n403 VSS.n402 1.74073
R1476 VSS.n482 VSS.n3 1.7005
R1477 VSS.n477 VSS.n476 1.7005
R1478 VSS.n432 VSS.n221 1.7005
R1479 VSS.n87 VSS.n81 1.56407
R1480 VSS.n486 VSS.n94 1.52216
R1481 VSS.n481 VSS.n128 1.52216
R1482 VSS.n223 VSS.n152 1.52209
R1483 VSS.n81 VSS.n78 1.50961
R1484 VSS.n399 VSS.n220 1.42992
R1485 VSS.n185 VSS.n184 1.42992
R1486 VSS.n186 VSS.n2 1.42992
R1487 VSS.n318 VSS.n298 1.40538
R1488 VSS.n450 VSS.n130 1.40538
R1489 VSS.n120 VSS.n100 1.40538
R1490 VSS.n298 VSS.n297 1.39498
R1491 VSS.n467 VSS.n130 1.39498
R1492 VSS.n100 VSS.n99 1.39498
R1493 VSS.n491 VSS.n2 1.2592
R1494 VSS.n190 VSS.n185 1.2592
R1495 VSS.n446 VSS.n220 1.2592
R1496 VSS.n187 VSS.n3 1.19921
R1497 VSS.n476 VSS.n182 1.19921
R1498 VSS.n400 VSS.n221 1.19921
R1499 VSS.n429 VSS.n428 1.19466
R1500 VSS.n87 VSS.n86 1.16981
R1501 VSS.n428 VSS.n427 0.788921
R1502 VSS.n428 VSS.n344 0.786818
R1503 VSS.n492 VSS.n491 0.713242
R1504 VSS.n313 VSS.n221 0.700561
R1505 VSS.n269 VSS.n221 0.700561
R1506 VSS.n271 VSS.n221 0.700561
R1507 VSS.n273 VSS.n221 0.700561
R1508 VSS.n275 VSS.n221 0.700561
R1509 VSS.n277 VSS.n221 0.700561
R1510 VSS.n279 VSS.n221 0.700561
R1511 VSS.n282 VSS.n221 0.700561
R1512 VSS.n284 VSS.n221 0.700561
R1513 VSS.n286 VSS.n221 0.700561
R1514 VSS.n288 VSS.n221 0.700561
R1515 VSS.n290 VSS.n221 0.700561
R1516 VSS.n292 VSS.n221 0.700561
R1517 VSS.n294 VSS.n221 0.700561
R1518 VSS.n115 VSS.n3 0.700314
R1519 VSS.n50 VSS.n3 0.700314
R1520 VSS.n52 VSS.n3 0.700314
R1521 VSS.n54 VSS.n3 0.700314
R1522 VSS.n56 VSS.n3 0.700314
R1523 VSS.n58 VSS.n3 0.700314
R1524 VSS.n60 VSS.n3 0.700314
R1525 VSS.n63 VSS.n3 0.700314
R1526 VSS.n65 VSS.n3 0.700314
R1527 VSS.n67 VSS.n3 0.700314
R1528 VSS.n69 VSS.n3 0.700314
R1529 VSS.n71 VSS.n3 0.700314
R1530 VSS.n73 VSS.n3 0.700314
R1531 VSS.n75 VSS.n3 0.700314
R1532 VSS.n476 VSS.n180 0.700314
R1533 VSS.n476 VSS.n178 0.700314
R1534 VSS.n476 VSS.n176 0.700314
R1535 VSS.n476 VSS.n174 0.700314
R1536 VSS.n476 VSS.n172 0.700314
R1537 VSS.n476 VSS.n170 0.700314
R1538 VSS.n476 VSS.n168 0.700314
R1539 VSS.n476 VSS.n166 0.700314
R1540 VSS.n476 VSS.n164 0.700314
R1541 VSS.n476 VSS.n162 0.700314
R1542 VSS.n476 VSS.n160 0.700314
R1543 VSS.n476 VSS.n158 0.700314
R1544 VSS.n476 VSS.n156 0.700314
R1545 VSS.n476 VSS.n153 0.700314
R1546 VSS.n88 VSS.n87 0.647262
R1547 VSS.n187 VSS.n186 0.611594
R1548 VSS.n184 VSS.n182 0.611594
R1549 VSS.n400 VSS.n399 0.611594
R1550 VSS.n402 VSS.n400 0.597096
R1551 VSS.n447 VSS.n182 0.597096
R1552 VSS.n189 VSS.n187 0.597096
R1553 VSS.n81 VSS.n0 0.50007
R1554 VSS.n420 VSS.n387 0.45681
R1555 VSS.n387 VSS.n386 0.450427
R1556 VSS.n421 VSS.n419 0.448698
R1557 VSS.n84 VSS.n83 0.328192
R1558 VSS.n421 VSS.n420 0.315541
R1559 VSS.n380 VSS.n379 0.309045
R1560 VSS.n407 VSS.n405 0.309045
R1561 VSS.n86 VSS.n85 0.285728
R1562 VSS.n439 VSS.n297 0.275819
R1563 VSS.n440 VSS.n439 0.275819
R1564 VSS.n319 VSS.n318 0.275819
R1565 VSS.n320 VSS.n319 0.275819
R1566 VSS.n469 VSS.n467 0.275819
R1567 VSS.n471 VSS.n469 0.275819
R1568 VSS.n451 VSS.n450 0.275819
R1569 VSS.n452 VSS.n451 0.275819
R1570 VSS.n99 VSS.n98 0.275819
R1571 VSS.n98 VSS.n97 0.275819
R1572 VSS.n121 VSS.n120 0.275819
R1573 VSS.n122 VSS.n121 0.275819
R1574 VSS.n85 VSS.n84 0.265083
R1575 VSS.n447 VSS.n446 0.261872
R1576 VSS.n190 VSS.n189 0.257491
R1577 VSS.n427 VSS.n345 0.250378
R1578 VSS.n375 VSS.n345 0.250378
R1579 VSS.n376 VSS.n375 0.250378
R1580 VSS.n377 VSS.n376 0.250378
R1581 VSS.n378 VSS.n377 0.250378
R1582 VSS.n379 VSS.n378 0.250378
R1583 VSS.n381 VSS.n380 0.250378
R1584 VSS.n382 VSS.n381 0.250378
R1585 VSS.n383 VSS.n382 0.250378
R1586 VSS.n384 VSS.n383 0.250378
R1587 VSS.n385 VSS.n384 0.250378
R1588 VSS.n386 VSS.n385 0.250378
R1589 VSS.n390 VSS.n344 0.250378
R1590 VSS.n392 VSS.n390 0.250378
R1591 VSS.n394 VSS.n392 0.250378
R1592 VSS.n396 VSS.n394 0.250378
R1593 VSS.n398 VSS.n396 0.250378
R1594 VSS.n409 VSS.n407 0.250378
R1595 VSS.n411 VSS.n409 0.250378
R1596 VSS.n413 VSS.n411 0.250378
R1597 VSS.n415 VSS.n413 0.250378
R1598 VSS.n417 VSS.n415 0.250378
R1599 VSS.n419 VSS.n417 0.250378
R1600 VSS.n440 VSS.n219 0.223034
R1601 VSS.n320 VSS.n267 0.223034
R1602 VSS.n472 VSS.n471 0.223034
R1603 VSS.n453 VSS.n452 0.223034
R1604 VSS.n97 VSS.n1 0.223034
R1605 VSS.n122 VSS.n48 0.223034
R1606 VSS.n82 VSS.n0 0.187772
R1607 VSS.n405 VSS.n403 0.167606
R1608 VSS.n484 VSS.n100 0.159417
R1609 VSS.n479 VSS.n130 0.159417
R1610 VSS.n434 VSS.n298 0.159417
R1611 VSS.n223 VSS.n221 0.150978
R1612 VSS.n94 VSS.n3 0.150921
R1613 VSS.n476 VSS.n128 0.150921
R1614 VSS.n3 VSS.n2 0.112733
R1615 VSS.n476 VSS.n185 0.112733
R1616 VSS.n221 VSS.n220 0.112733
R1617 VSS.n83 VSS.n82 0.0997723
R1618 VSS.n403 VSS.n398 0.0832723
R1619 VSS.n27 VSS.n25 0.0423341
R1620 VSS.n204 VSS.n167 0.0423341
R1621 VSS.n246 VSS.n244 0.0423341
R1622 VSS.n25 VSS.n24 0.0423341
R1623 VSS.n204 VSS.n165 0.0423341
R1624 VSS.n244 VSS.n243 0.0423341
R1625 VSS.n446 VSS.n219 0.0357621
R1626 VSS.n472 VSS.n190 0.0357621
R1627 VSS.n491 VSS.n1 0.0357621
R1628 VSS.n189 VSS.n48 0.0357621
R1629 VSS.n453 VSS.n447 0.0357621
R1630 VSS.n402 VSS.n267 0.0357621
R1631 VSS.n489 VSS.n4 0.0345652
R1632 VSS.n9 VSS.n7 0.0345652
R1633 VSS.n12 VSS.n10 0.0345652
R1634 VSS.n15 VSS.n13 0.0345652
R1635 VSS.n18 VSS.n16 0.0345652
R1636 VSS.n21 VSS.n19 0.0345652
R1637 VSS.n24 VSS.n22 0.0345652
R1638 VSS.n30 VSS.n28 0.0345652
R1639 VSS.n33 VSS.n31 0.0345652
R1640 VSS.n36 VSS.n34 0.0345652
R1641 VSS.n39 VSS.n37 0.0345652
R1642 VSS.n42 VSS.n40 0.0345652
R1643 VSS.n45 VSS.n43 0.0345652
R1644 VSS.n474 VSS.n154 0.0345652
R1645 VSS.n193 VSS.n155 0.0345652
R1646 VSS.n195 VSS.n157 0.0345652
R1647 VSS.n197 VSS.n159 0.0345652
R1648 VSS.n199 VSS.n161 0.0345652
R1649 VSS.n201 VSS.n163 0.0345652
R1650 VSS.n203 VSS.n165 0.0345652
R1651 VSS.n206 VSS.n169 0.0345652
R1652 VSS.n208 VSS.n171 0.0345652
R1653 VSS.n210 VSS.n173 0.0345652
R1654 VSS.n212 VSS.n175 0.0345652
R1655 VSS.n214 VSS.n177 0.0345652
R1656 VSS.n216 VSS.n179 0.0345652
R1657 VSS.n444 VSS.n222 0.0345652
R1658 VSS.n228 VSS.n226 0.0345652
R1659 VSS.n231 VSS.n229 0.0345652
R1660 VSS.n234 VSS.n232 0.0345652
R1661 VSS.n237 VSS.n235 0.0345652
R1662 VSS.n240 VSS.n238 0.0345652
R1663 VSS.n243 VSS.n241 0.0345652
R1664 VSS.n249 VSS.n247 0.0345652
R1665 VSS.n252 VSS.n250 0.0345652
R1666 VSS.n255 VSS.n253 0.0345652
R1667 VSS.n258 VSS.n256 0.0345652
R1668 VSS.n261 VSS.n259 0.0345652
R1669 VSS.n264 VSS.n262 0.0345652
R1670 VSS.n46 VSS.n45 0.0345652
R1671 VSS.n43 VSS.n42 0.0345652
R1672 VSS.n40 VSS.n39 0.0345652
R1673 VSS.n37 VSS.n36 0.0345652
R1674 VSS.n34 VSS.n33 0.0345652
R1675 VSS.n31 VSS.n30 0.0345652
R1676 VSS.n28 VSS.n27 0.0345652
R1677 VSS.n22 VSS.n21 0.0345652
R1678 VSS.n19 VSS.n18 0.0345652
R1679 VSS.n16 VSS.n15 0.0345652
R1680 VSS.n13 VSS.n12 0.0345652
R1681 VSS.n10 VSS.n9 0.0345652
R1682 VSS.n7 VSS.n4 0.0345652
R1683 VSS.n218 VSS.n179 0.0345652
R1684 VSS.n216 VSS.n177 0.0345652
R1685 VSS.n214 VSS.n175 0.0345652
R1686 VSS.n212 VSS.n173 0.0345652
R1687 VSS.n210 VSS.n171 0.0345652
R1688 VSS.n208 VSS.n169 0.0345652
R1689 VSS.n206 VSS.n167 0.0345652
R1690 VSS.n203 VSS.n163 0.0345652
R1691 VSS.n201 VSS.n161 0.0345652
R1692 VSS.n199 VSS.n159 0.0345652
R1693 VSS.n197 VSS.n157 0.0345652
R1694 VSS.n195 VSS.n155 0.0345652
R1695 VSS.n193 VSS.n154 0.0345652
R1696 VSS.n265 VSS.n264 0.0345652
R1697 VSS.n262 VSS.n261 0.0345652
R1698 VSS.n259 VSS.n258 0.0345652
R1699 VSS.n256 VSS.n255 0.0345652
R1700 VSS.n253 VSS.n252 0.0345652
R1701 VSS.n250 VSS.n249 0.0345652
R1702 VSS.n247 VSS.n246 0.0345652
R1703 VSS.n241 VSS.n240 0.0345652
R1704 VSS.n238 VSS.n237 0.0345652
R1705 VSS.n235 VSS.n234 0.0345652
R1706 VSS.n232 VSS.n231 0.0345652
R1707 VSS.n229 VSS.n228 0.0345652
R1708 VSS.n226 VSS.n222 0.0345652
R1709 VSS.n491 VSS.n490 0.0335973
R1710 VSS.n189 VSS.n188 0.0335973
R1711 VSS.n475 VSS.n190 0.0335973
R1712 VSS.n447 VSS.n181 0.0335973
R1713 VSS.n446 VSS.n445 0.0335973
R1714 VSS.n402 VSS.n401 0.0335973
R1715 VSS.n88 VSS.n79 0.031851
R1716 VSS.n490 VSS.n489 0.0175326
R1717 VSS.n475 VSS.n474 0.0175326
R1718 VSS.n445 VSS.n444 0.0175326
R1719 VSS.n188 VSS.n46 0.0175326
R1720 VSS.n218 VSS.n181 0.0175326
R1721 VSS.n401 VSS.n265 0.0175326
R1722 VSS.n89 VSS.n88 0.00198959
R1723 VSS.n442 VSS.n441 0.00166667
R1724 VSS.n470 VSS.n127 0.00166667
R1725 VSS.n487 VSS.n77 0.00166667
R1726 VSS.n488 VSS.n487 0.00133332
R1727 VSS.n473 VSS.n127 0.00133332
R1728 VSS.n443 VSS.n442 0.00133332
R1729 VSS.n91 VSS.n78 0.00103963
R1730 VSS.n89 VSS.n78 0.00101041
R1731 VSS.n430 VSS.n338 0.001
R1732 VSS.n338 VSS.n323 0.001
R1733 VSS.n389 VSS.n324 0.001
R1734 VSS.n391 VSS.n325 0.001
R1735 VSS.n393 VSS.n326 0.001
R1736 VSS.n395 VSS.n327 0.001
R1737 VSS.n397 VSS.n328 0.001
R1738 VSS.n404 VSS.n329 0.001
R1739 VSS.n406 VSS.n330 0.001
R1740 VSS.n408 VSS.n331 0.001
R1741 VSS.n410 VSS.n332 0.001
R1742 VSS.n412 VSS.n333 0.001
R1743 VSS.n414 VSS.n334 0.001
R1744 VSS.n416 VSS.n335 0.001
R1745 VSS.n418 VSS.n336 0.001
R1746 VSS.n436 VSS.n435 0.001
R1747 VSS.n437 VSS.n436 0.001
R1748 VSS.n438 VSS.n296 0.001
R1749 VSS.n433 VSS.n315 0.001
R1750 VSS.n316 VSS.n315 0.001
R1751 VSS.n322 VSS.n317 0.001
R1752 VSS.n321 VSS.n266 0.001
R1753 VSS.n480 VSS.n129 0.001
R1754 VSS.n129 VSS.n125 0.001
R1755 VSS.n468 VSS.n126 0.001
R1756 VSS.n478 VSS.n147 0.001
R1757 VSS.n149 VSS.n147 0.001
R1758 VSS.n449 VSS.n150 0.001
R1759 VSS.n448 VSS.n151 0.001
R1760 VSS.n485 VSS.n95 0.001
R1761 VSS.n95 VSS.n92 0.001
R1762 VSS.n96 VSS.n93 0.001
R1763 VSS.n483 VSS.n117 0.001
R1764 VSS.n118 VSS.n117 0.001
R1765 VSS.n124 VSS.n119 0.001
R1766 VSS.n123 VSS.n47 0.001
R1767 VSS.n88 VSS.n80 0.001
R1768 VSS.n80 VSS.n78 0.001
R1769 VSS.n484 VSS.n483 0.001
R1770 VSS.n485 VSS.n484 0.001
R1771 VSS.n96 VSS.n92 0.001
R1772 VSS.n93 VSS.n77 0.001
R1773 VSS.n488 VSS.n47 0.001
R1774 VSS.n124 VSS.n123 0.001
R1775 VSS.n119 VSS.n118 0.001
R1776 VSS.n479 VSS.n478 0.001
R1777 VSS.n480 VSS.n479 0.001
R1778 VSS.n468 VSS.n125 0.001
R1779 VSS.n470 VSS.n126 0.001
R1780 VSS.n473 VSS.n151 0.001
R1781 VSS.n448 VSS.n150 0.001
R1782 VSS.n449 VSS.n149 0.001
R1783 VSS.n434 VSS.n433 0.001
R1784 VSS.n435 VSS.n434 0.001
R1785 VSS.n438 VSS.n437 0.001
R1786 VSS.n441 VSS.n296 0.001
R1787 VSS.n443 VSS.n266 0.001
R1788 VSS.n322 VSS.n321 0.001
R1789 VSS.n317 VSS.n316 0.001
R1790 VSS.n426 VSS.n339 0.001
R1791 VSS.n426 VSS.n425 0.001
R1792 VSS.n348 VSS.n346 0.001
R1793 VSS.n374 VSS.n349 0.001
R1794 VSS.n373 VSS.n350 0.001
R1795 VSS.n372 VSS.n351 0.001
R1796 VSS.n371 VSS.n352 0.001
R1797 VSS.n370 VSS.n353 0.001
R1798 VSS.n369 VSS.n354 0.001
R1799 VSS.n368 VSS.n355 0.001
R1800 VSS.n367 VSS.n356 0.001
R1801 VSS.n366 VSS.n357 0.001
R1802 VSS.n365 VSS.n358 0.001
R1803 VSS.n364 VSS.n359 0.001
R1804 VSS.n423 VSS.n360 0.001
R1805 VSS.n429 VSS.n339 0.001
R1806 VSS.n430 VSS.n429 0.001
R1807 VSS.n423 VSS.n422 0.001
R1808 VSS.n360 VSS.n359 0.001
R1809 VSS.n364 VSS.n358 0.001
R1810 VSS.n365 VSS.n357 0.001
R1811 VSS.n366 VSS.n356 0.001
R1812 VSS.n367 VSS.n355 0.001
R1813 VSS.n368 VSS.n354 0.001
R1814 VSS.n369 VSS.n353 0.001
R1815 VSS.n370 VSS.n352 0.001
R1816 VSS.n371 VSS.n351 0.001
R1817 VSS.n372 VSS.n350 0.001
R1818 VSS.n373 VSS.n349 0.001
R1819 VSS.n374 VSS.n348 0.001
R1820 VSS.n425 VSS.n346 0.001
R1821 VSS.n389 VSS.n323 0.001
R1822 VSS.n391 VSS.n324 0.001
R1823 VSS.n393 VSS.n325 0.001
R1824 VSS.n395 VSS.n326 0.001
R1825 VSS.n397 VSS.n327 0.001
R1826 VSS.n404 VSS.n328 0.001
R1827 VSS.n406 VSS.n329 0.001
R1828 VSS.n408 VSS.n330 0.001
R1829 VSS.n410 VSS.n331 0.001
R1830 VSS.n412 VSS.n332 0.001
R1831 VSS.n414 VSS.n333 0.001
R1832 VSS.n416 VSS.n334 0.001
R1833 VSS.n418 VSS.n335 0.001
R1834 VSS.n422 VSS.n336 0.001
R1835 a_8732_725.t0 a_8732_725.t1 28.1924
R1836 a_6064_725.t0 a_6064_725.t1 28.1928
R1837 a_3387_725.t0 a_3387_725.t1 28.1928
R1838 a_4264_1495.t1 a_4264_1495.n0 14.2913
R1839 a_4264_1495.n0 a_4264_1495.n1 3.8175
R1840 a_4264_1495.n1 a_4264_1495.t3 24.9817
R1841 a_4264_1495.n1 a_4264_1495.t2 24.6077
R1842 a_4264_1495.n0 a_4264_1495.t0 12.817
R1843 a_1587_1495.t1 a_1587_1495.n0 14.2913
R1844 a_1587_1495.n0 a_1587_1495.n1 3.8439
R1845 a_1587_1495.n1 a_1587_1495.t3 24.9839
R1846 a_1587_1495.n1 a_1587_1495.t2 24.6077
R1847 a_1587_1495.n0 a_1587_1495.t0 12.8112
R1848 a_9620_3460.t1 a_9620_3460.n0 14.6095
R1849 a_9620_3460.n0 a_9620_3460.n1 0.2315
R1850 a_9620_3460.n1 a_9620_3460.t3 25.0785
R1851 a_9620_3460.n1 a_9620_3460.t2 24.7001
R1852 a_9620_3460.n0 a_9620_3460.t0 12.9028
R1853 a_1519_1531.t1 a_1519_1531.n0 14.2913
R1854 a_1519_1531.n0 a_1519_1531.n2 26.4093
R1855 a_1519_1531.n2 a_1519_1531.n3 2.6119
R1856 a_1519_1531.n3 a_1519_1531.t5 24.9575
R1857 a_1519_1531.n3 a_1519_1531.t2 24.6077
R1858 a_1519_1531.n2 a_1519_1531.n1 2.6911
R1859 a_1519_1531.n1 a_1519_1531.t4 24.9971
R1860 a_1519_1531.n1 a_1519_1531.t3 24.8035
R1861 a_1519_1531.n0 a_1519_1531.t0 12.8173
R1862 a_8732_2713.t0 a_8732_2713.t1 24.9004
R1863 a_6064_3981.t0 a_6064_3981.t1 24.9004
R1864 a_3387_2714.t0 a_3387_2714.t1 24.902
R1865 a_379_2010.t0 a_379_2010.n0 19.8861
R1866 a_379_2010.n0 a_379_2010.n1 4.2025
R1867 a_379_2010.n1 a_379_2010.n2 5.8965
R1868 a_379_2010.n2 a_379_2010.t3 30.7281
R1869 a_379_2010.n2 a_379_2010.t4 24.8607
R1870 a_379_2010.n1 a_379_2010.t1 24.2535
R1871 a_379_2010.n1 a_379_2010.t5 24.8607
R1872 a_379_2010.n0 a_379_2010.t2 14.4684
C2 Vcon VSS 13.67854f
C3 Vout VSS 0.83469f
C4 VDD VSS 2.50993f
C5 m2_9092_2412# VSS 0.04282f
C6 a_379_2010.t0 VSS 0.17278f $ **FLOATING
C7 a_379_2010.t2 VSS 0.22803f $ **FLOATING
C8 a_379_2010.n0 VSS 0.70062f $ **FLOATING
C9 a_379_2010.t5 VSS 3.8597f $ **FLOATING
C10 a_379_2010.t1 VSS 3.85944f $ **FLOATING
C11 a_379_2010.n1 VSS 0.41647f $ **FLOATING
C12 a_379_2010.t4 VSS 3.8597f $ **FLOATING
C13 a_379_2010.n2 VSS 0.65228f $ **FLOATING
C14 a_379_2010.t3 VSS 3.90871f $ **FLOATING
C15 a_3387_2714.t0 VSS 0.33157f $ **FLOATING
C16 a_3387_2714.t1 VSS 0.33157f $ **FLOATING
C17 a_6064_3981.t0 VSS 0.33314f $ **FLOATING
C18 a_6064_3981.t1 VSS 0.33214f $ **FLOATING
C19 a_8732_2713.t0 VSS 0.34881f $ **FLOATING
C20 a_8732_2713.t1 VSS 0.34864f $ **FLOATING
C21 a_1519_1531.t1 VSS 0.0963f $ **FLOATING
C22 a_1519_1531.t0 VSS 0.20061f $ **FLOATING
C23 a_1519_1531.n0 VSS 0.98266f $ **FLOATING
C24 a_1519_1531.t3 VSS 0.04341f $ **FLOATING
C25 a_1519_1531.t4 VSS 0.07433f $ **FLOATING
C26 a_1519_1531.n1 VSS 0.21653f $ **FLOATING
C27 a_1519_1531.n2 VSS 1.00264f $ **FLOATING
C28 a_1519_1531.t2 VSS 1.87391f $ **FLOATING
C29 a_1519_1531.t5 VSS 3.73282f $ **FLOATING
C30 a_1519_1531.n3 VSS 0.19854f $ **FLOATING
C31 a_9620_3460.t1 VSS 0.17857f $ **FLOATING
C32 a_9620_3460.t0 VSS 0.38101f $ **FLOATING
C33 a_9620_3460.n0 VSS 0.2876f $ **FLOATING
C34 a_9620_3460.t2 VSS 0.07307f $ **FLOATING
C35 a_9620_3460.t3 VSS 0.1261f $ **FLOATING
C36 a_9620_3460.n1 VSS 0.22851f $ **FLOATING
C37 a_1587_1495.t1 VSS 0.07315f $ **FLOATING
C38 a_1587_1495.t0 VSS 0.15297f $ **FLOATING
C39 a_1587_1495.n0 VSS 0.20631f $ **FLOATING
C40 a_1587_1495.t2 VSS 1.42347f $ **FLOATING
C41 a_1587_1495.t3 VSS 2.83387f $ **FLOATING
C42 a_1587_1495.n1 VSS 0.18129f $ **FLOATING
C43 a_4264_1495.t1 VSS 0.0728f $ **FLOATING
C44 a_4264_1495.t0 VSS 0.15165f $ **FLOATING
C45 a_4264_1495.n0 VSS 0.20455f $ **FLOATING
C46 a_4264_1495.t2 VSS 1.4167f $ **FLOATING
C47 a_4264_1495.t3 VSS 2.82039f $ **FLOATING
C48 a_4264_1495.n1 VSS 0.1797f $ **FLOATING
C49 a_3387_725.t0 VSS 0.05817f $ **FLOATING
C50 a_3387_725.t1 VSS 0.05817f $ **FLOATING
C51 a_6064_725.t0 VSS 0.0582f $ **FLOATING
C52 a_6064_725.t1 VSS 0.0582f $ **FLOATING
C53 a_8732_725.t0 VSS 0.12513f $ **FLOATING
C54 a_8732_725.t1 VSS 0.12514f $ **FLOATING
C55 VDD.n0 VSS 0.07878f $ **FLOATING
C56 VDD.t1 VSS 0.0518f $ **FLOATING
C57 VDD.n1 VSS 0.03316f $ **FLOATING
C58 VDD.t2 VSS 0.0518f $ **FLOATING
C59 VDD.n3 VSS 0.04292f $ **FLOATING
C60 VDD.n4 VSS 0.02111f $ **FLOATING
C61 VDD.n5 VSS 0.34587f $ **FLOATING
C62 VDD.n6 VSS 0.18512f $ **FLOATING
C63 VDD.n60 VSS 0.0773f $ **FLOATING
C64 VDD.n61 VSS 0.04893f $ **FLOATING
C65 VDD.t8 VSS 0.04827f $ **FLOATING
C66 VDD.n70 VSS 0.0562f $ **FLOATING
C67 VDD.n71 VSS 0.34587f $ **FLOATING
C68 VDD.n72 VSS 0.34587f $ **FLOATING
C69 VDD.n73 VSS 0.34587f $ **FLOATING
C70 VDD.n74 VSS 0.34587f $ **FLOATING
C71 VDD.n75 VSS 0.34587f $ **FLOATING
C72 VDD.n76 VSS 0.34587f $ **FLOATING
C73 VDD.n77 VSS 0.34587f $ **FLOATING
C74 VDD.n78 VSS 0.34587f $ **FLOATING
C75 VDD.t3 VSS 0.4069f $ **FLOATING
C76 VDD.n79 VSS 0.34587f $ **FLOATING
C77 VDD.n80 VSS 0.34587f $ **FLOATING
C78 VDD.n81 VSS 0.34587f $ **FLOATING
C79 VDD.n82 VSS 0.34587f $ **FLOATING
C80 VDD.n83 VSS 0.34587f $ **FLOATING
C81 VDD.n84 VSS 0.34587f $ **FLOATING
C82 VDD.n85 VSS 0.34587f $ **FLOATING
C83 VDD.n87 VSS 0.03524f $ **FLOATING
C84 VDD.n88 VSS 0.05334f $ **FLOATING
C85 VDD.n99 VSS 0.06706f $ **FLOATING
C86 VDD.n100 VSS 0.34587f $ **FLOATING
C87 VDD.n101 VSS 0.34587f $ **FLOATING
C88 VDD.n102 VSS 0.34587f $ **FLOATING
C89 VDD.n103 VSS 0.34587f $ **FLOATING
C90 VDD.n104 VSS 0.34587f $ **FLOATING
C91 VDD.n105 VSS 0.34587f $ **FLOATING
C92 VDD.n106 VSS 0.34587f $ **FLOATING
C93 VDD.n107 VSS 0.34587f $ **FLOATING
C94 VDD.t5 VSS 0.4565f $ **FLOATING
C95 VDD.n108 VSS 0.29628f $ **FLOATING
C96 VDD.n109 VSS 0.34587f $ **FLOATING
C97 VDD.n110 VSS 0.34587f $ **FLOATING
C98 VDD.n111 VSS 0.34587f $ **FLOATING
C99 VDD.n112 VSS 0.34587f $ **FLOATING
C100 VDD.n113 VSS 0.34587f $ **FLOATING
C101 VDD.n114 VSS 0.34587f $ **FLOATING
C102 VDD.n115 VSS 0.34587f $ **FLOATING
C103 VDD.t9 VSS 0.04827f $ **FLOATING
C104 VDD.n116 VSS 0.06113f $ **FLOATING
C105 VDD.n117 VSS 0.01138f $ **FLOATING
C106 VDD.n118 VSS 0.34587f $ **FLOATING
C107 VDD.n121 VSS 0.43013f $ **FLOATING
C108 VDD.n132 VSS 0.01265f $ **FLOATING
C109 VDD.n133 VSS 0.01265f $ **FLOATING
C110 VDD.n136 VSS 0.01099f $ **FLOATING
C111 VDD.n139 VSS 0.01319f $ **FLOATING
C112 VDD.n146 VSS 0.0221f $ **FLOATING
C113 VDD.n148 VSS 0.01265f $ **FLOATING
C114 VDD.n149 VSS 0.05488f $ **FLOATING
C115 VDD.n150 VSS 0.01265f $ **FLOATING
C116 VDD.n151 VSS 0.01265f $ **FLOATING
C117 VDD.n152 VSS 0.01265f $ **FLOATING
C118 VDD.n153 VSS 0.01265f $ **FLOATING
C119 VDD.n154 VSS 0.01265f $ **FLOATING
C120 VDD.n155 VSS 0.01265f $ **FLOATING
C121 VDD.n156 VSS 0.01265f $ **FLOATING
C122 VDD.n157 VSS 0.01265f $ **FLOATING
C123 VDD.n158 VSS 0.01265f $ **FLOATING
C124 VDD.n159 VSS 0.01265f $ **FLOATING
C125 VDD.n160 VSS 0.01265f $ **FLOATING
C126 VDD.n161 VSS 0.01265f $ **FLOATING
C127 VDD.n162 VSS 0.01265f $ **FLOATING
C128 VDD.n163 VSS 0.01265f $ **FLOATING
C129 VDD.n164 VSS 0.01265f $ **FLOATING
C130 VDD.n165 VSS 0.01265f $ **FLOATING
C131 VDD.n166 VSS 0.01486f $ **FLOATING
C132 VDD.n167 VSS 0.0127f $ **FLOATING
C133 VDD.n168 VSS 0.01486f $ **FLOATING
C134 VDD.n169 VSS 0.01265f $ **FLOATING
C135 VDD.n170 VSS 0.01265f $ **FLOATING
C136 VDD.n171 VSS 0.01265f $ **FLOATING
C137 VDD.n172 VSS 0.01265f $ **FLOATING
C138 VDD.n173 VSS 0.01265f $ **FLOATING
C139 VDD.n174 VSS 0.01265f $ **FLOATING
C140 VDD.n175 VSS 0.01265f $ **FLOATING
C141 VDD.n176 VSS 0.01265f $ **FLOATING
C142 VDD.n177 VSS 0.01265f $ **FLOATING
C143 VDD.n178 VSS 0.01265f $ **FLOATING
C144 VDD.n179 VSS 0.01265f $ **FLOATING
C145 VDD.n180 VSS 0.01265f $ **FLOATING
C146 VDD.n181 VSS 0.01265f $ **FLOATING
C147 VDD.n183 VSS 0.01265f $ **FLOATING
C148 VDD.n184 VSS 0.01265f $ **FLOATING
C149 VDD.n188 VSS 0.01258f $ **FLOATING
C150 VDD.n189 VSS 0.01258f $ **FLOATING
C151 VDD.n190 VSS 0.01258f $ **FLOATING
C152 VDD.n191 VSS 0.01258f $ **FLOATING
C153 VDD.n192 VSS 0.01258f $ **FLOATING
C154 VDD.n193 VSS 0.01478f $ **FLOATING
C155 VDD.n194 VSS 0.01478f $ **FLOATING
C156 VDD.n195 VSS 0.01258f $ **FLOATING
C157 VDD.n196 VSS 0.01258f $ **FLOATING
C158 VDD.n197 VSS 0.01258f $ **FLOATING
C159 VDD.n198 VSS 0.01258f $ **FLOATING
C160 VDD.n199 VSS 0.01258f $ **FLOATING
C161 VDD.n200 VSS 0.01258f $ **FLOATING
C162 VDD.n201 VSS 0.01258f $ **FLOATING
C163 VDD.n202 VSS 0.01258f $ **FLOATING
C164 VDD.n203 VSS 0.03841f $ **FLOATING
C165 VDD.n205 VSS 0.0281f $ **FLOATING
C166 VDD.t6 VSS 6.60798f $ **FLOATING
C167 VDD.t10 VSS 0.04787f $ **FLOATING
C168 VDD.n208 VSS 0.04394f $ **FLOATING
C169 VDD.n240 VSS 0.02863f $ **FLOATING
C170 VDD.n255 VSS 0.02341f $ **FLOATING
C171 VDD.n256 VSS 0.02492f $ **FLOATING
C172 VDD.n257 VSS 0.07767f $ **FLOATING
C173 VDD.n259 VSS 0.01258f $ **FLOATING
C174 VDD.n260 VSS 0.01258f $ **FLOATING
C175 VDD.n261 VSS 0.01258f $ **FLOATING
C176 VDD.n262 VSS 0.01258f $ **FLOATING
C177 VDD.n263 VSS 0.01258f $ **FLOATING
C178 VDD.n264 VSS 0.01258f $ **FLOATING
C179 VDD.n265 VSS 0.01258f $ **FLOATING
C180 VDD.n266 VSS 0.01263f $ **FLOATING
C181 VDD.n267 VSS 0.01258f $ **FLOATING
C182 VDD.n268 VSS 0.01258f $ **FLOATING
C183 VDD.n269 VSS 0.01258f $ **FLOATING
C184 VDD.n270 VSS 0.01258f $ **FLOATING
C185 VDD.n271 VSS 0.01258f $ **FLOATING
C186 VDD.n272 VSS 0.01258f $ **FLOATING
C187 VDD.t7 VSS 0.04955f $ **FLOATING
C188 VDD.n274 VSS 0.02681f $ **FLOATING
C189 VDD.n275 VSS 0.01027f $ **FLOATING
C190 VDD.n276 VSS 0.01258f $ **FLOATING
C191 VDD.n277 VSS 0.01258f $ **FLOATING
C192 VDD.n278 VSS 0.22389f $ **FLOATING
C193 VDD.n280 VSS 0.01258f $ **FLOATING
C194 VDD.n281 VSS 0.43013f $ **FLOATING
C195 VDD.n282 VSS 0.02109f $ **FLOATING
C196 VDD.n283 VSS 0.10496f $ **FLOATING
C197 VDD.n284 VSS 0.18519f $ **FLOATING
C198 VDD.n285 VSS 0.08544f $ **FLOATING
C199 VDD.n286 VSS 0.06792f $ **FLOATING
C200 VDD.n287 VSS 0.18526f $ **FLOATING
C201 VDD.n290 VSS 0.01265f $ **FLOATING
C202 VDD.n292 VSS 0.01265f $ **FLOATING
C203 VDD.n294 VSS 0.01265f $ **FLOATING
C204 VDD.n296 VSS 0.01265f $ **FLOATING
C205 VDD.n298 VSS 0.01265f $ **FLOATING
C206 VDD.n300 VSS 0.01265f $ **FLOATING
C207 VDD.n302 VSS 0.01486f $ **FLOATING
C208 VDD.n304 VSS 0.01486f $ **FLOATING
C209 VDD.n306 VSS 0.01265f $ **FLOATING
C210 VDD.n308 VSS 0.01265f $ **FLOATING
C211 VDD.n310 VSS 0.01265f $ **FLOATING
C212 VDD.n312 VSS 0.01265f $ **FLOATING
C213 VDD.n314 VSS 0.01265f $ **FLOATING
C214 VDD.n316 VSS 0.01265f $ **FLOATING
C215 VDD.n318 VSS 0.01265f $ **FLOATING
C216 VDD.n320 VSS 0.01265f $ **FLOATING
C217 VDD.n323 VSS 0.01265f $ **FLOATING
C218 VDD.n326 VSS 0.01265f $ **FLOATING
C219 VDD.n329 VSS 0.01265f $ **FLOATING
C220 VDD.n332 VSS 0.01265f $ **FLOATING
C221 VDD.n335 VSS 0.01265f $ **FLOATING
C222 VDD.n338 VSS 0.01265f $ **FLOATING
C223 VDD.n341 VSS 0.0127f $ **FLOATING
C224 VDD.n344 VSS 0.01265f $ **FLOATING
C225 VDD.n347 VSS 0.01265f $ **FLOATING
C226 VDD.n350 VSS 0.01265f $ **FLOATING
C227 VDD.n353 VSS 0.01265f $ **FLOATING
C228 VDD.n356 VSS 0.01265f $ **FLOATING
C229 VDD.n359 VSS 0.01265f $ **FLOATING
C230 VDD.n362 VSS 0.01265f $ **FLOATING
C231 VDD.n368 VSS 0.04121f $ **FLOATING
C232 VDD.n373 VSS 0.01099f $ **FLOATING
C233 VDD.n381 VSS 0.06699f $ **FLOATING
C234 VDD.n383 VSS 0.01265f $ **FLOATING
C235 VDD.n384 VSS 0.43013f $ **FLOATING
C236 VDD.n385 VSS 0.01265f $ **FLOATING
C237 VDD.n386 VSS 0.01265f $ **FLOATING
C238 VDD.t4 VSS 3.90984f $ **FLOATING
C239 VDD.n392 VSS 0.16036f $ **FLOATING
C240 VDD.n394 VSS 0.59128f $ **FLOATING
C241 VDD.n458 VSS 0.34587f $ **FLOATING
C242 VDD.n461 VSS 0.08649f $ **FLOATING
C243 VDD.n462 VSS 0.03028f $ **FLOATING
C244 VDD.n463 VSS 0.02725f $ **FLOATING
C245 VDD.n464 VSS 0.14447f $ **FLOATING
C246 VDD.n465 VSS 0.06688f $ **FLOATING
C247 VDD.n466 VSS 0.04126f $ **FLOATING
C248 VDD.n474 VSS 0.01099f $ **FLOATING
C249 VDD.n481 VSS 0.01192f $ **FLOATING
C250 VDD.n486 VSS 0.43013f $ **FLOATING
C251 VDD.t0 VSS 1.91138f $ **FLOATING
C252 VDD.n488 VSS 0.26649f $ **FLOATING
C253 VDD.n490 VSS 0.04883f $ **FLOATING
C254 Vout.t0 VSS 0.36375f $ **FLOATING
C255 Vout.t1 VSS 0.17352f $ **FLOATING
C256 Vout.n0 VSS 0.26489f $ **FLOATING
C257 Vcon.t2 VSS 0.63812f $ **FLOATING
C258 Vcon.t1 VSS 0.63812f $ **FLOATING
C259 Vcon.t0 VSS 0.653f $ **FLOATING
C260 Vcon.n0 VSS 0.20096f $ **FLOATING
C261 Vcon.n1 VSS 0.13927f $ **FLOATING
C262 Vcon.t3 VSS 0.63717f $ **FLOATING
C263 Vcon.n2 VSS 0.0844f $ **FLOATING
.ends
