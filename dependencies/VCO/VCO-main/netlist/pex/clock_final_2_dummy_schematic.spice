.subckt clock_final_2 VDD VSS
.ends
.end
